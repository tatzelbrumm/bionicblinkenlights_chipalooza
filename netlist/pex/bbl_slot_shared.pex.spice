*********************************************************
*** NGSPICE file created by KLayout-PEX 0.6.8
*** -----------------------------------------------------
***     Extraction Engine: KPEX/2.5D
***     Technology: ihp_sg13cmos5l
***     Date: 2026-11-09 00:55:38
*********************************************************

.SUBCKT bbl_slot_shared \$14.sa \$14.vbn \$14.vbp analog_bus0 analog_bus1
+ analog_bus2 analog_bus3 dig_in[0] dig_in[10] dig_in[11] dig_in[12] dig_in[13]
+ dig_in[14] dig_in[15] dig_in[16] dig_in[17] dig_in[18] dig_in[19] dig_in[1]
+ dig_in[20] dig_in[21] dig_in[22] dig_in[23] dig_in[2] dig_in[3] dig_in[4]
+ dig_in[5] dig_in[6] dig_in[7] dig_in[8] dig_in[9] dig_out[0] dig_out[10]
+ dig_out[11] dig_out[1] dig_out[2] dig_out[3] dig_out[4] dig_out[5] dig_out[6]
+ dig_out[7] dig_out[8] dig_out[9] enable sub! vbias vdd_1v2 vdd_3v3 vss_1v2
+ vss_3v3
X$1 dig_out[0] vss_3v3 vss_1v2 vdd_1v2 dig_out[2] dig_out[1] dig_out[7]
+ dig_out[6] dig_out[5] dig_out[4] dig_out[3] dig_out[10] dig_out[9] dig_out[8]
+ dig_out[11] sub! bbl_tielo
X$2 \$84 vdd_3v3 analog_bus0 vss_3v3 sub! bbl_inv
X$3 \$91 vdd_3v3 analog_bus1 vss_3v3 sub! bbl_inv
X$4 analog_bus2 vss_3v3 \$90 dig_in[22] dig_in[23] \$96 sub! bbl_gap
X$5 vss_3v3 \$89 \$85 dig_in[0] dig_in[1] dig_in[2] dig_in[3] vdd_3v3 \$84 sub!
+ bbl_unit
X$6 vss_3v3 \$95 \$85 dig_in[8] dig_in[9] dig_in[10] dig_in[11] vdd_3v3 \$92
+ sub! bbl_unit
X$7 vss_3v3 \$96 \$85 dig_in[12] dig_in[13] dig_in[14] dig_in[15] vdd_3v3 \$93
+ sub! bbl_unit
X$8 vss_3v3 dig_in[16] dig_in[17] \$97 vdd_3v3 \$94 sub! bbl_syn
X$9 vss_3v3 dig_in[18] dig_in[19] \$98 vdd_3v3 \$89 sub! bbl_syn
X$10 \$89 vss_3v3 vbias dig_in[20] dig_in[21] \$94 sub! bbl_gap
X$11 vss_3v3 \$94 \$85 dig_in[4] dig_in[5] dig_in[6] dig_in[7] vdd_3v3 \$91
+ sub! bbl_unit
X$12 \$84 vdd_3v3 \$97 vss_3v3 sub! bbl_inv
X$13 \$91 vdd_3v3 \$98 vss_3v3 sub! bbl_inv
X$1 \$87 \$88 sub! rhigh w=5e-07 l=4.1055e-05 ps=1.8e-07 b=9 m=1
X$2 \$86 enable vss_1v2 sub! sg13_lv_nmos w=3e-07 l=5e-07 as=1.02e-13
+ ad=1.02e-13 ps=1.28e-06 pd=1.28e-06
X$3 \$86 enable vdd_1v2 \$I52 sg13_lv_pmos w=3e-07 l=5e-07 as=1.02e-13
+ ad=1.02e-13 ps=1.28e-06 pd=1.28e-06
X$4 vss_3v3 vbias vss_3v3 sub! sg13_hv_nmos w=1e-05 l=1e-05 as=3.4e-12
+ ad=1.9e-12 ps=2.068e-05 pd=1.038e-05
X$5 vss_3v3 vbias vss_3v3 sub! sg13_hv_nmos w=1e-05 l=1e-05 as=1.9e-12
+ ad=1.9e-12 ps=1.038e-05 pd=1.038e-05
X$6 vss_3v3 vbias vss_3v3 sub! sg13_hv_nmos w=1e-05 l=1e-05 as=1.9e-12
+ ad=1.9e-12 ps=1.038e-05 pd=1.038e-05
X$7 vss_3v3 vbias vss_3v3 sub! sg13_hv_nmos w=1e-05 l=1e-05 as=1.9e-12
+ ad=1.9e-12 ps=1.038e-05 pd=1.038e-05
X$8 vss_3v3 vbias vss_3v3 sub! sg13_hv_nmos w=1e-05 l=1e-05 as=1.9e-12
+ ad=3.4e-12 ps=1.038e-05 pd=2.068e-05
X$9 vss_3v3 \$90 vss_3v3 sub! sg13_hv_nmos w=1e-05 l=1e-05 as=3.4e-12
+ ad=1.9e-12 ps=2.068e-05 pd=1.038e-05
X$10 vss_3v3 \$90 vss_3v3 sub! sg13_hv_nmos w=1e-05 l=1e-05 as=1.9e-12
+ ad=1.9e-12 ps=1.038e-05 pd=1.038e-05
X$11 vss_3v3 \$90 vss_3v3 sub! sg13_hv_nmos w=1e-05 l=1e-05 as=1.9e-12
+ ad=1.9e-12 ps=1.038e-05 pd=1.038e-05
X$12 vss_3v3 \$90 vss_3v3 sub! sg13_hv_nmos w=1e-05 l=1e-05 as=1.9e-12
+ ad=1.9e-12 ps=1.038e-05 pd=1.038e-05
X$13 vss_3v3 \$90 vss_3v3 sub! sg13_hv_nmos w=1e-05 l=1e-05 as=1.9e-12
+ ad=3.4e-12 ps=1.038e-05 pd=2.068e-05
X$14 analog_bus2 \$90 \$95 sub! sg13_hv_nmos w=1e-06 l=4.5e-07 as=3.4e-13
+ ad=3.4e-13 ps=2.68e-06 pd=2.68e-06
X$15 analog_bus3 \$90 \$96 sub! sg13_hv_nmos w=1e-06 l=4.5e-07 as=3.4e-13
+ ad=3.4e-13 ps=2.68e-06 pd=2.68e-06
X$16 \$14.sa enable vss_3v3 sub! sg13_hv_nmos w=1e-06 l=4.5e-07 as=3.4e-13
+ ad=3.4e-13 ps=2.68e-06 pd=2.68e-06
X$17 \$88 enable vss_3v3 sub! sg13_hv_nmos w=1e-06 l=4.5e-07 as=3.4e-13
+ ad=3.4e-13 ps=2.68e-06 pd=2.68e-06
X$18 \$14.vbn \$86 vss_3v3 sub! sg13_hv_nmos w=1e-06 l=4.5e-07 as=3.4e-13
+ ad=3.4e-13 ps=2.68e-06 pd=2.68e-06
X$19 \$14.vbp \$14.vbn \$87 sub! sg13_hv_nmos w=2e-06 l=2e-06 as=6.8e-13
+ ad=3.8e-13 ps=4.68e-06 pd=2.38e-06
X$20 \$87 \$14.vbn \$14.vbp sub! sg13_hv_nmos w=2e-06 l=2e-06 as=3.8e-13
+ ad=3.8e-13 ps=2.38e-06 pd=2.38e-06
X$21 \$14.vbp \$14.vbn \$87 sub! sg13_hv_nmos w=2e-06 l=2e-06 as=3.8e-13
+ ad=3.8e-13 ps=2.38e-06 pd=2.38e-06
X$22 \$87 \$14.vbn \$14.vbp sub! sg13_hv_nmos w=2e-06 l=2e-06 as=3.8e-13
+ ad=3.8e-13 ps=2.38e-06 pd=2.38e-06
X$23 \$14.vbp \$14.vbn \$87 sub! sg13_hv_nmos w=2e-06 l=2e-06 as=3.8e-13
+ ad=3.8e-13 ps=2.38e-06 pd=2.38e-06
X$24 \$87 \$14.vbn \$14.vbp sub! sg13_hv_nmos w=2e-06 l=2e-06 as=3.8e-13
+ ad=3.8e-13 ps=2.38e-06 pd=2.38e-06
X$25 \$14.vbp \$14.vbn \$87 sub! sg13_hv_nmos w=2e-06 l=2e-06 as=3.8e-13
+ ad=3.8e-13 ps=2.38e-06 pd=2.38e-06
X$26 \$87 \$14.vbn \$14.vbp sub! sg13_hv_nmos w=2e-06 l=2e-06 as=3.8e-13
+ ad=6.8e-13 ps=2.38e-06 pd=4.68e-06
X$27 \$85 \$85 vss_3v3 sub! sg13_hv_nmos w=2e-06 l=2e-06 as=6.8e-13 ad=6.8e-13
+ ps=4.68e-06 pd=4.68e-06
X$28 \$14.vbn \$14.vbn \$14.sa sub! sg13_hv_nmos w=2e-06 l=2e-06 as=6.8e-13
+ ad=6.8e-13 ps=4.68e-06 pd=4.68e-06
X$29 \$90 \$14.vbp vdd_3v3 \$I80 sg13_hv_pmos w=3e-07 l=2.2e-05 as=1.02e-13
+ ad=1.02e-13 ps=1.28e-06 pd=1.28e-06
X$30 vbias \$14.vbp vdd_3v3 \$I80 sg13_hv_pmos w=3e-07 l=2.2e-05 as=1.02e-13
+ ad=1.02e-13 ps=1.28e-06 pd=1.28e-06
X$31 \$85 \$14.vbp vdd_3v3 \$I80 sg13_hv_pmos w=3e-07 l=8e-06 as=1.02e-13
+ ad=1.02e-13 ps=1.28e-06 pd=1.28e-06
X$32 \$14.vbn vdd_3v3 vdd_3v3 \$I80 sg13_hv_pmos w=4e-06 l=4.5e-07 as=1.36e-12
+ ad=1.36e-12 ps=8.68e-06 pd=8.68e-06
X$33 \$14.vbn \$14.vbp vdd_3v3 \$I80 sg13_hv_pmos w=2e-06 l=2e-06 as=6.8e-13
+ ad=6.8e-13 ps=4.68e-06 pd=4.68e-06
X$34 \$14.vbp \$14.vbp vdd_3v3 \$I80 sg13_hv_pmos w=2e-06 l=2e-06 as=6.8e-13
+ ad=6.8e-13 ps=4.68e-06 pd=4.68e-06
X$35 vdd_1v2 \$I52 ntap1
X$36 vdd_1v2 \$I52 ntap1
X$37 vdd_3v3 \$I80 ntap1
X$38 vdd_3v3 \$I80 ntap1
X$39 vdd_3v3 \$I80 ntap1
X$40 vdd_3v3 \$I80 ntap1
X$41 vdd_3v3 \$I80 ntap1
X$42 vdd_3v3 \$I80 ntap1
X$43 vdd_3v3 \$I80 ntap1
X$44 vdd_3v3 \$I80 ntap1
X$45 vdd_3v3 \$I80 ntap1
X$46 vdd_3v3 \$I80 ntap1
X$47 vdd_3v3 \$I80 ntap1
X$48 vdd_3v3 \$I80 ntap1
X$49 vdd_3v3 \$I80 ntap1
X$50 vdd_3v3 \$I80 ntap1
X$51 vdd_3v3 \$I80 ntap1
X$52 vdd_3v3 \$I80 ntap1
X$53 vdd_3v3 \$I80 ntap1
X$54 vdd_3v3 \$I80 ntap1
X$55 vdd_3v3 \$I80 ntap1
X$56 vdd_3v3 \$I80 ntap1
X$57 vdd_3v3 \$I80 ntap1
X$58 vdd_3v3 \$I80 ntap1
X$59 vdd_3v3 \$I80 ntap1
X$60 vdd_3v3 \$I80 ntap1
X$61 vdd_3v3 \$I80 ntap1
X$62 vdd_3v3 \$I80 ntap1
X$63 vdd_3v3 \$I80 ntap1
X$64 vdd_3v3 \$I80 ntap1
X$65 vdd_3v3 \$I80 ntap1
X$66 vdd_3v3 \$I80 ntap1
X$67 vdd_3v3 \$I80 ntap1
X$68 vdd_3v3 \$I80 ntap1
X$69 vdd_3v3 \$I80 ntap1
X$70 vdd_3v3 \$I80 ntap1
X$71 vdd_3v3 \$I80 ntap1
X$72 vdd_3v3 \$I80 ntap1
X$73 vdd_3v3 \$I80 ntap1
X$74 vss_3v3 sub! ptap1
X$75 vss_3v3 sub! ptap1
X$76 vss_3v3 sub! ptap1
X$77 vss_3v3 sub! ptap1
X$78 vss_3v3 sub! ptap1
X$79 vss_3v3 sub! ptap1
X$80 vss_3v3 sub! ptap1
X$81 vss_3v3 sub! ptap1
X$82 vss_3v3 sub! ptap1
X$83 vss_3v3 sub! ptap1
X$84 vss_3v3 sub! ptap1
X$85 vss_3v3 sub! ptap1
X$86 vss_3v3 sub! ptap1
X$87 vss_3v3 sub! ptap1
X$88 vss_3v3 sub! ptap1
X$89 vss_3v3 sub! ptap1
X$90 vss_3v3 sub! ptap1
X$91 vss_3v3 sub! ptap1
X$92 vss_3v3 sub! ptap1
X$93 vss_3v3 sub! ptap1
X$94 vss_3v3 sub! ptap1
X$95 vss_3v3 sub! ptap1
X$96 vss_3v3 sub! ptap1
X$97 vss_3v3 sub! ptap1
X$98 vss_3v3 sub! ptap1
X$99 vss_3v3 sub! ptap1
X$100 vss_3v3 sub! ptap1
X$101 vss_3v3 sub! ptap1
X$102 vss_3v3 sub! ptap1
X$103 vss_3v3 sub! ptap1
X$104 vss_3v3 sub! ptap1
X$105 vss_3v3 sub! ptap1
X$106 vss_3v3 sub! ptap1
X$107 vss_3v3 sub! ptap1
X$108 vss_3v3 sub! ptap1
X$109 vss_3v3 sub! ptap1
X$110 vss_3v3 sub! ptap1
X$111 vss_3v3 sub! ptap1
X$112 vss_3v3 sub! ptap1
X$113 vss_3v3 sub! ptap1
X$114 vss_3v3 sub! ptap1
Cext_1 \$14.sa \$14.vbn 315.396a
Cext_2 \$14.sa \$14.vbp 2.34769f
Cext_3 \$14.sa \$85 56.2206a
Cext_4 \$14.sa \$86 2.34172f
Cext_5 \$14.sa \$87 41.5673a
Cext_6 \$14.sa \$88 52.5973a
Cext_7 \$14.sa \$90 48.0252a
Cext_8 \$14.sa \$I80 11.8691a
Cext_9 \$14.sa enable 672.111a
Cext_10 \$14.sa vbias 46.8545a
Cext_11 \$14.sa vdd_3v3 534.217a
Cext_12 \$14.sa vss_3v3 245.395a
Cext_13 \$14.sa sub! 656.612a
Cext_14 \$14.vbn \$14.vbp 4.10042f
Cext_15 \$14.vbn \$85 127.427a
Cext_16 \$14.vbn \$86 824.924a
Cext_17 \$14.vbn \$87 1.05784f
Cext_18 \$14.vbn \$88 92.7653a
Cext_19 \$14.vbn \$90 100.951a
Cext_20 \$14.vbn \$I80 892.841a
Cext_21 \$14.vbn enable 77.8383a
Cext_22 \$14.vbn vbias 122.798a
Cext_23 \$14.vbn vdd_1v2 1.5191a
Cext_24 \$14.vbn vdd_3v3 1.12565f
Cext_25 \$14.vbn vss_3v3 491.069a
Cext_26 \$14.vbn sub! 4.45886f
Cext_27 \$14.vbp \$85 368.631a
Cext_28 \$14.vbp \$86 709.904a
Cext_29 \$14.vbp \$87 548.012a
Cext_30 \$14.vbp \$88 104.127a
Cext_31 \$14.vbp \$90 208.3a
Cext_32 \$14.vbp \$I80 8.11251f
Cext_33 \$14.vbp enable 93.422a
Cext_34 \$14.vbp vbias 214.433a
Cext_35 \$14.vbp vdd_3v3 975.645a
Cext_36 \$14.vbp vss_3v3 158.185a
Cext_37 \$14.vbp sub! 3.24012f
Cext_38 \$19 \$89 160.327a
Cext_39 \$19 \$94 334.772a
Cext_40 \$19 \$97 374.308a
Cext_41 \$19 \$98 335.608a
Cext_42 \$19 analog_bus0 618.799a
Cext_43 \$19 bs 25.8706a
Cext_44 \$19 bw 72.8405a
Cext_45 \$19 dig_in[16] 27.763a
Cext_46 \$19 dig_in[17] 164.366a
Cext_47 \$19 dig_in[18] 15.0979a
Cext_48 \$19 dig_in[19] 136.061a
Cext_49 \$19 gs 9.94849f
Cext_50 \$19 gw 30.3705f
Cext_51 \$19 vdd_1v2 2.13312f
Cext_52 \$19 vdd_3v3 18.8242f
Cext_53 \$19 vss_3v3 12.9354f
Cext_54 \$238 analog_bus0 2.75322a
Cext_55 \$238 analog_bus1 0.230404a
Cext_56 \$238 analog_bus2 0.154122a
Cext_57 \$238 analog_bus3 0.109718a
Cext_58 \$238 clk 10.6138a
Cext_59 \$238 vbias 127.725a
Cext_60 \$238 vss_1v2 48.765a
Cext_61 \$238 sub! 68.1424a
Cext_62 \$239 analog_bus0 2.75322a
Cext_63 \$239 analog_bus1 0.230404a
Cext_64 \$239 analog_bus2 0.154122a
Cext_65 \$239 analog_bus3 0.109718a
Cext_66 \$239 ibias0 127.725a
Cext_67 \$239 vbias 127.725a
Cext_68 \$239 vss_1v2 9.16252a
Cext_69 \$239 sub! 31.9a
Cext_70 \$241 analog_bus0 2.75322a
Cext_71 \$241 analog_bus1 0.230404a
Cext_72 \$241 analog_bus2 0.154122a
Cext_73 \$241 analog_bus3 0.109718a
Cext_74 \$241 ibias0 127.725a
Cext_75 \$241 ibias1 127.725a
Cext_76 \$241 vss_1v2 2.79293a
Cext_77 \$241 sub! 31.9a
Cext_78 \$243 analog_bus0 2.75322a
Cext_79 \$243 analog_bus1 0.230404a
Cext_80 \$243 analog_bus2 0.154122a
Cext_81 \$243 analog_bus3 127.835a
Cext_82 \$243 ibias1 127.725a
Cext_83 \$243 vss_1v2 1.07212a
Cext_84 \$243 sub! 31.9a
Cext_85 \$246 analog_bus0 2.75322a
Cext_86 \$246 analog_bus1 127.956a
Cext_87 \$246 analog_bus2 127.725a
Cext_88 \$246 vss_3v3 1.47958a
Cext_89 \$246 sub! 31.9a
Cext_90 \$247 analog_bus0 2.75322a
Cext_91 \$247 analog_bus1 0.230404a
Cext_92 \$247 analog_bus2 127.88a
Cext_93 \$247 analog_bus3 127.725a
Cext_94 \$247 vss_3v3 0.244588a
Cext_95 \$247 sub! 31.9a
Cext_96 \$248 analog_bus0 130.479a
Cext_97 \$248 analog_bus1 127.725a
Cext_98 \$248 vss_3v3 4.25665a
Cext_99 \$248 sub! 31.9a
Cext_100 \$249 analog_bus0 127.725a
Cext_101 \$249 vss_3v3 59.9549a
Cext_102 \$249 sub! 89.9303a
Cext_103 \$30 \$84 803.081a
Cext_104 \$30 \$85 692.621a
Cext_105 \$30 \$89 220.381f
Cext_106 \$30 \$91 877.425a
Cext_107 \$30 \$92 991.493a
Cext_108 \$30 \$93 1.41465f
Cext_109 \$30 \$94 220.455f
Cext_110 \$30 \$95 220.568f
Cext_111 \$30 \$96 221.899f
Cext_112 \$30 dig_in[0] 1.01283a
Cext_113 \$30 dig_in[10] 389.584a
Cext_114 \$30 dig_in[11] 193.638a
Cext_115 \$30 dig_in[12] 479.678a
Cext_116 \$30 dig_in[13] 221.337a
Cext_117 \$30 dig_in[14] 224.755a
Cext_118 \$30 dig_in[15] 689.017a
Cext_119 \$30 dig_in[1] 1.38142a
Cext_120 \$30 dig_in[2] 1.58673a
Cext_121 \$30 dig_in[3] 43.4706a
Cext_122 \$30 dig_in[4] 75.5899a
Cext_123 \$30 dig_in[5] 75.9122a
Cext_124 \$30 dig_in[6] 76.9499a
Cext_125 \$30 dig_in[7] 119.262a
Cext_126 \$30 dig_in[8] 300.9a
Cext_127 \$30 dig_in[9] 187.961a
Cext_128 \$30 rst 2.89734f
Cext_129 \$30 s0 85.3417a
Cext_130 \$30 s1 128.589a
Cext_131 \$30 s2 968.001a
Cext_132 \$30 s3 1.48709f
Cext_133 \$30 slow 3.83702f
Cext_134 \$30 vdd_3v3 79.973f
Cext_135 \$30 vin 28.6388f
Cext_136 \$30 vss_3v3 23.2431f
Cext_137 \$5 \$84 766.087a
Cext_138 \$5 \$91 768.118a
Cext_139 \$5 \$97 194.267a
Cext_140 \$5 \$98 179.151a
Cext_141 \$5 analog_bus0 116.231a
Cext_142 \$5 analog_bus1 116.171a
Cext_143 \$5 dig_in[21] 1.70665a
Cext_144 \$5 gw 4.98097a
Cext_145 \$5 vdd_3v3 2.20855f
Cext_146 \$5 vss_3v3 368.137a
Cext_147 \$84 \$85 24.9682f
Cext_148 \$84 \$86 25.9126f
Cext_149 \$84 \$87 182.328a
Cext_150 \$84 \$88 26.5519a
Cext_151 \$84 \$89 21.3958f
Cext_152 \$84 \$90 16.2887a
Cext_153 \$84 \$91 25.2541f
Cext_154 \$84 \$92 12.7597a
Cext_155 \$84 \$93 12.3992a
Cext_156 \$84 \$94 31.2992a
Cext_157 \$84 \$95 11.9807a
Cext_158 \$84 \$96 19.3185a
Cext_159 \$84 \$97 1.12938f
Cext_160 \$84 \$98 11.9807a
Cext_161 \$84 analog_bus0 1.09702f
Cext_162 \$84 analog_bus1 25.187a
Cext_163 \$84 analog_bus2 37.1677a
Cext_164 \$84 analog_bus3 42.9194a
Cext_165 \$84 dig_in[0] 65.4568a
Cext_166 \$84 dig_in[10] 32.7097a
Cext_167 \$84 dig_in[11] 32.4238a
Cext_168 \$84 dig_in[12] 54.0899a
Cext_169 \$84 dig_in[13] 38.9644a
Cext_170 \$84 dig_in[14] 33.9757a
Cext_171 \$84 dig_in[15] 29.0895a
Cext_172 \$84 dig_in[16] 0.357939a
Cext_173 \$84 dig_in[1] 65.4407a
Cext_174 \$84 dig_in[20] 42.9194a
Cext_175 \$84 dig_in[21] 31.2398a
Cext_176 \$84 dig_in[22] 31.2398a
Cext_177 \$84 dig_in[23] 42.006a
Cext_178 \$84 dig_in[2] 63.955a
Cext_179 \$84 dig_in[3] 4.18632f
Cext_180 \$84 dig_in[4] 28.2175a
Cext_181 \$84 dig_in[5] 28.2694a
Cext_182 \$84 dig_in[6] 28.2694a
Cext_183 \$84 dig_in[7] 28.2175a
Cext_184 \$84 dig_in[8] 28.2694a
Cext_185 \$84 dig_in[9] 35.6071a
Cext_186 \$84 dig_out[0] 31.2398a
Cext_187 \$84 dig_out[10] 31.2398a
Cext_188 \$84 dig_out[11] 31.2398a
Cext_189 \$84 dig_out[1] 31.2398a
Cext_190 \$84 dig_out[2] 31.2398a
Cext_191 \$84 dig_out[3] 31.2398a
Cext_192 \$84 dig_out[4] 31.2398a
Cext_193 \$84 dig_out[5] 31.2398a
Cext_194 \$84 dig_out[6] 31.2398a
Cext_195 \$84 dig_out[7] 31.2398a
Cext_196 \$84 dig_out[8] 31.2398a
Cext_197 \$84 dig_out[9] 31.2398a
Cext_198 \$84 enable 42.006a
Cext_199 \$84 rst 213.42a
Cext_200 \$84 s0 30.487a
Cext_201 \$84 s1 49.1341a
Cext_202 \$84 s2 266.49a
Cext_203 \$84 s3 166.535a
Cext_204 \$84 slow 99.6514a
Cext_205 \$84 vbias 50.9659a
Cext_206 \$84 vdd_1v2 325.967a
Cext_207 \$84 vdd_3v3 10.2707f
Cext_208 \$84 vin 265.208a
Cext_209 \$84 vss_1v2 310.076a
Cext_210 \$84 vss_3v3 5.89064f
Cext_211 \$84 sub! 7.82765f
Cext_212 \$85 \$86 64.6471a
Cext_213 \$85 \$87 175.871a
Cext_214 \$85 \$88 3.74309f
Cext_215 \$85 \$89 1.68264f
Cext_216 \$85 \$90 814.817a
Cext_217 \$85 \$91 21.1539f
Cext_218 \$85 \$92 21.1613f
Cext_219 \$85 \$93 30.641f
Cext_220 \$85 \$94 7.35525f
Cext_221 \$85 \$95 1.55127f
Cext_222 \$85 \$96 1.06927f
Cext_223 \$85 \$I80 88.1493a
Cext_224 \$85 analog_bus0 17.9086a
Cext_225 \$85 analog_bus1 11.9807a
Cext_226 \$85 analog_bus2 11.9807a
Cext_227 \$85 analog_bus3 15.5964a
Cext_228 \$85 dig_in[0] 21.0406f
Cext_229 \$85 dig_in[10] 130.121a
Cext_230 \$85 dig_in[11] 109.074a
Cext_231 \$85 dig_in[12] 21.0753f
Cext_232 \$85 dig_in[13] 106.907a
Cext_233 \$85 dig_in[14] 101.669a
Cext_234 \$85 dig_in[15] 115.223a
Cext_235 \$85 dig_in[16] 11.9807a
Cext_236 \$85 dig_in[17] 11.9807a
Cext_237 \$85 dig_in[18] 11.9807a
Cext_238 \$85 dig_in[19] 14.3547a
Cext_239 \$85 dig_in[1] 79.4104a
Cext_240 \$85 dig_in[20] 14.3547a
Cext_241 \$85 dig_in[21] 11.9807a
Cext_242 \$85 dig_in[22] 11.9807a
Cext_243 \$85 dig_in[23] 14.3547a
Cext_244 \$85 dig_in[2] 74.4299a
Cext_245 \$85 dig_in[3] 91.6457a
Cext_246 \$85 dig_in[4] 21.0763f
Cext_247 \$85 dig_in[5] 112.784a
Cext_248 \$85 dig_in[6] 107.546a
Cext_249 \$85 dig_in[7] 105.896a
Cext_250 \$85 dig_in[8] 21.083f
Cext_251 \$85 dig_in[9] 123.273a
Cext_252 \$85 dig_out[0] 11.9807a
Cext_253 \$85 dig_out[10] 11.9807a
Cext_254 \$85 dig_out[11] 11.9807a
Cext_255 \$85 dig_out[1] 11.9807a
Cext_256 \$85 dig_out[2] 11.9807a
Cext_257 \$85 dig_out[3] 11.9807a
Cext_258 \$85 dig_out[4] 11.9807a
Cext_259 \$85 dig_out[5] 11.9807a
Cext_260 \$85 dig_out[6] 11.9807a
Cext_261 \$85 dig_out[7] 11.9807a
Cext_262 \$85 dig_out[8] 11.9807a
Cext_263 \$85 dig_out[9] 11.9807a
Cext_264 \$85 enable 72.9661a
Cext_265 \$85 rst 303.465a
Cext_266 \$85 s0 673.598a
Cext_267 \$85 s1 890.783a
Cext_268 \$85 s2 1.36057f
Cext_269 \$85 s3 2.36553f
Cext_270 \$85 slow 214.321a
Cext_271 \$85 vbias 11.0374f
Cext_272 \$85 vdd_1v2 105.737a
Cext_273 \$85 vdd_3v3 27.1804f
Cext_274 \$85 vin 5.18664f
Cext_275 \$85 vss_1v2 485.684a
Cext_276 \$85 vss_3v3 3.47334f
Cext_277 \$85 sub! 45.0926f
Cext_278 \$86 \$87 3.87433f
Cext_279 \$86 \$88 11.0212f
Cext_280 \$86 \$89 36.4041a
Cext_281 \$86 \$90 128.41a
Cext_282 \$86 \$91 258.97a
Cext_283 \$86 \$92 0.418531a
Cext_284 \$86 \$93 0.25014a
Cext_285 \$86 \$94 45.747a
Cext_286 \$86 \$95 19.0908a
Cext_287 \$86 \$96 52.8572a
Cext_288 \$86 \$97 36.5524a
Cext_289 \$86 \$98 36.0353a
Cext_290 \$86 \$I52 136.596a
Cext_291 \$86 \$I80 1.57987f
Cext_292 \$86 analog_bus0 17.9086a
Cext_293 \$86 analog_bus1 11.9807a
Cext_294 \$86 analog_bus2 11.9807a
Cext_295 \$86 analog_bus3 15.5964a
Cext_296 \$86 dig_in[10] 27.5771a
Cext_297 \$86 dig_in[11] 23.9614a
Cext_298 \$86 dig_in[12] 23.9614a
Cext_299 \$86 dig_in[13] 23.9614a
Cext_300 \$86 dig_in[14] 23.9614a
Cext_301 \$86 dig_in[15] 23.9614a
Cext_302 \$86 dig_in[16] 11.9807a
Cext_303 \$86 dig_in[17] 11.9807a
Cext_304 \$86 dig_in[18] 11.9807a
Cext_305 \$86 dig_in[19] 14.3547a
Cext_306 \$86 dig_in[1] 0.264512a
Cext_307 \$86 dig_in[20] 14.3547a
Cext_308 \$86 dig_in[21] 11.9807a
Cext_309 \$86 dig_in[22] 11.9807a
Cext_310 \$86 dig_in[23] 14.3547a
Cext_311 \$86 dig_in[2] 0.67623a
Cext_312 \$86 dig_in[3] 16.8523a
Cext_313 \$86 dig_in[4] 26.3354a
Cext_314 \$86 dig_in[5] 23.9614a
Cext_315 \$86 dig_in[6] 23.9614a
Cext_316 \$86 dig_in[7] 23.9614a
Cext_317 \$86 dig_in[8] 23.9614a
Cext_318 \$86 dig_in[9] 31.2992a
Cext_319 \$86 dig_out[0] 40.9822a
Cext_320 \$86 dig_out[10] 34.1288a
Cext_321 \$86 dig_out[11] 34.1288a
Cext_322 \$86 dig_out[1] 34.1288a
Cext_323 \$86 dig_out[2] 34.1288a
Cext_324 \$86 dig_out[3] 34.1288a
Cext_325 \$86 dig_out[4] 34.1288a
Cext_326 \$86 dig_out[5] 34.1288a
Cext_327 \$86 dig_out[6] 34.1288a
Cext_328 \$86 dig_out[7] 34.1288a
Cext_329 \$86 dig_out[8] 34.1288a
Cext_330 \$86 dig_out[9] 1.54616f
Cext_331 \$86 enable 4.75031f
Cext_332 \$86 vbias 30.6249f
Cext_333 \$86 vdd_1v2 849.626a
Cext_334 \$86 vdd_3v3 291.977a
Cext_335 \$86 vss_1v2 666.935a
Cext_336 \$86 vss_3v3 797.037a
Cext_337 \$86 sub! 8.22733f
Cext_338 \$87 \$88 45.6359f
Cext_339 \$87 \$89 37.6458a
Cext_340 \$87 \$90 11.1283f
Cext_341 \$87 \$91 5.25532f
Cext_342 \$87 \$92 26.8312a
Cext_343 \$87 \$93 78.4228a
Cext_344 \$87 \$94 46.9888a
Cext_345 \$87 \$95 16.7168a
Cext_346 \$87 \$96 48.1092a
Cext_347 \$87 \$97 41.4099a
Cext_348 \$87 \$98 39.651a
Cext_349 \$87 \$I80 40.2557a
Cext_350 \$87 analog_bus0 17.9086a
Cext_351 \$87 analog_bus1 11.9807a
Cext_352 \$87 analog_bus2 11.9807a
Cext_353 \$87 analog_bus3 15.5964a
Cext_354 \$87 dig_in[10] 31.8851a
Cext_355 \$87 dig_in[11] 28.2694a
Cext_356 \$87 dig_in[12] 28.2694a
Cext_357 \$87 dig_in[13] 28.2694a
Cext_358 \$87 dig_in[14] 28.2694a
Cext_359 \$87 dig_in[15] 28.2694a
Cext_360 \$87 dig_in[16] 11.9807a
Cext_361 \$87 dig_in[17] 11.9807a
Cext_362 \$87 dig_in[18] 11.9807a
Cext_363 \$87 dig_in[19] 14.3547a
Cext_364 \$87 dig_in[20] 14.3547a
Cext_365 \$87 dig_in[21] 11.9807a
Cext_366 \$87 dig_in[22] 11.9807a
Cext_367 \$87 dig_in[23] 14.3547a
Cext_368 \$87 dig_in[2] 0.404156a
Cext_369 \$87 dig_in[3] 4.66414a
Cext_370 \$87 dig_in[4] 30.6434a
Cext_371 \$87 dig_in[5] 28.2694a
Cext_372 \$87 dig_in[6] 28.2694a
Cext_373 \$87 dig_in[7] 28.2694a
Cext_374 \$87 dig_in[8] 28.2694a
Cext_375 \$87 dig_in[9] 28.2694a
Cext_376 \$87 dig_out[0] 11.9807a
Cext_377 \$87 dig_out[10] 11.9807a
Cext_378 \$87 dig_out[11] 11.9807a
Cext_379 \$87 dig_out[1] 11.9807a
Cext_380 \$87 dig_out[2] 11.9807a
Cext_381 \$87 dig_out[3] 11.9807a
Cext_382 \$87 dig_out[4] 11.9807a
Cext_383 \$87 dig_out[5] 11.9807a
Cext_384 \$87 dig_out[6] 11.9807a
Cext_385 \$87 dig_out[7] 11.9807a
Cext_386 \$87 dig_out[8] 11.9807a
Cext_387 \$87 dig_out[9] 98.7987a
Cext_388 \$87 enable 11.0232f
Cext_389 \$87 vbias 196.539a
Cext_390 \$87 vdd_1v2 105.737a
Cext_391 \$87 vdd_3v3 730.171a
Cext_392 \$87 vss_1v2 614.546a
Cext_393 \$87 vss_3v3 559.816a
Cext_394 \$87 sub! 15.5704f
Cext_395 \$88 \$89 35.8389a
Cext_396 \$88 \$90 2.28069f
Cext_397 \$88 \$91 16.0967a
Cext_398 \$88 \$92 15.5964a
Cext_399 \$88 \$93 22.9342a
Cext_400 \$88 \$94 43.0595a
Cext_401 \$88 \$95 20.104a
Cext_402 \$88 \$96 50.8366a
Cext_403 \$88 \$97 14.5362f
Cext_404 \$88 \$98 258.25a
Cext_405 \$88 \$I80 32.5317a
Cext_406 \$88 analog_bus0 17.9086a
Cext_407 \$88 analog_bus1 11.9807a
Cext_408 \$88 analog_bus2 11.9807a
Cext_409 \$88 analog_bus3 15.5964a
Cext_410 \$88 dig_in[10] 31.1929a
Cext_411 \$88 dig_in[11] 27.5771a
Cext_412 \$88 dig_in[12] 27.5771a
Cext_413 \$88 dig_in[13] 27.5771a
Cext_414 \$88 dig_in[14] 27.5771a
Cext_415 \$88 dig_in[15] 27.5771a
Cext_416 \$88 dig_in[16] 11.9807a
Cext_417 \$88 dig_in[17] 11.9807a
Cext_418 \$88 dig_in[18] 11.9807a
Cext_419 \$88 dig_in[19] 14.3547a
Cext_420 \$88 dig_in[20] 14.3547a
Cext_421 \$88 dig_in[21] 11.9807a
Cext_422 \$88 dig_in[22] 11.9807a
Cext_423 \$88 dig_in[23] 14.3547a
Cext_424 \$88 dig_in[2] 0.264512a
Cext_425 \$88 dig_in[3] 0.404156a
Cext_426 \$88 dig_in[4] 29.9511a
Cext_427 \$88 dig_in[5] 27.5771a
Cext_428 \$88 dig_in[6] 27.5771a
Cext_429 \$88 dig_in[7] 27.5771a
Cext_430 \$88 dig_in[8] 27.5771a
Cext_431 \$88 dig_in[9] 27.5771a
Cext_432 \$88 dig_out[0] 11.9807a
Cext_433 \$88 dig_out[10] 11.9807a
Cext_434 \$88 dig_out[11] 11.9807a
Cext_435 \$88 dig_out[1] 11.9807a
Cext_436 \$88 dig_out[2] 11.9807a
Cext_437 \$88 dig_out[3] 11.9807a
Cext_438 \$88 dig_out[4] 11.9807a
Cext_439 \$88 dig_out[5] 11.9807a
Cext_440 \$88 dig_out[6] 11.9807a
Cext_441 \$88 dig_out[7] 11.9807a
Cext_442 \$88 dig_out[8] 11.9807a
Cext_443 \$88 dig_out[9] 11.9807a
Cext_444 \$88 enable 11.5687f
Cext_445 \$88 vbias 71.3777a
Cext_446 \$88 vdd_1v2 105.737a
Cext_447 \$88 vdd_3v3 316.778a
Cext_448 \$88 vss_1v2 1.1104f
Cext_449 \$88 vss_3v3 460.781a
Cext_450 \$88 sub! 13.9989f
Cext_451 \$89 \$90 27.2501f
Cext_452 \$89 \$91 46.3495a
Cext_453 \$89 \$92 30.62a
Cext_454 \$89 \$93 30.4121a
Cext_455 \$89 \$94 34.6487f
Cext_456 \$89 \$95 14.5293a
Cext_457 \$89 \$96 20.7623a
Cext_458 \$89 \$97 27.3484a
Cext_459 \$89 \$98 15.9275f
Cext_460 \$89 \$I80 0.599677a
Cext_461 \$89 analog_bus0 17.9086a
Cext_462 \$89 analog_bus1 11.9807a
Cext_463 \$89 analog_bus2 30.7147a
Cext_464 \$89 analog_bus3 35.7162a
Cext_465 \$89 bs 34.0351a
Cext_466 \$89 bw 48.6554a
Cext_467 \$89 dig_in[0] 99.6498a
Cext_468 \$89 dig_in[10] 52.3992a
Cext_469 \$89 dig_in[11] 58.5683a
Cext_470 \$89 dig_in[12] 34.5831a
Cext_471 \$89 dig_in[13] 30.0464a
Cext_472 \$89 dig_in[14] 30.0337a
Cext_473 \$89 dig_in[15] 31.78a
Cext_474 \$89 dig_in[16] 11.9807a
Cext_475 \$89 dig_in[17] 11.9288a
Cext_476 \$89 dig_in[18] 12.7766f
Cext_477 \$89 dig_in[19] 75.2826a
Cext_478 \$89 dig_in[1] 102.81a
Cext_479 \$89 dig_in[20] 42.8172a
Cext_480 \$89 dig_in[21] 36.8087a
Cext_481 \$89 dig_in[22] 29.8764a
Cext_482 \$89 dig_in[23] 34.7276a
Cext_483 \$89 dig_in[2] 102.952a
Cext_484 \$89 dig_in[3] 106.688a
Cext_485 \$89 dig_in[4] 57.4926a
Cext_486 \$89 dig_in[5] 41.9516a
Cext_487 \$89 dig_in[6] 35.9066a
Cext_488 \$89 dig_in[7] 34.2419a
Cext_489 \$89 dig_in[8] 31.0974a
Cext_490 \$89 dig_in[9] 30.9125a
Cext_491 \$89 dig_out[0] 23.9614a
Cext_492 \$89 dig_out[10] 23.9614a
Cext_493 \$89 dig_out[11] 23.9614a
Cext_494 \$89 dig_out[1] 23.9614a
Cext_495 \$89 dig_out[2] 23.9614a
Cext_496 \$89 dig_out[3] 23.9614a
Cext_497 \$89 dig_out[4] 23.9614a
Cext_498 \$89 dig_out[5] 23.9614a
Cext_499 \$89 dig_out[6] 23.9614a
Cext_500 \$89 dig_out[7] 23.9614a
Cext_501 \$89 dig_out[8] 23.9614a
Cext_502 \$89 dig_out[9] 26.3354a
Cext_503 \$89 enable 34.7276a
Cext_504 \$89 gs 178.064a
Cext_505 \$89 gw 148.646a
Cext_506 \$89 rst 1.683f
Cext_507 \$89 s0 115.017a
Cext_508 \$89 s1 176.72a
Cext_509 \$89 s2 110.597a
Cext_510 \$89 s3 166.535a
Cext_511 \$89 slow 1.20463f
Cext_512 \$89 vbias 6.06292f
Cext_513 \$89 vdd_1v2 218.616a
Cext_514 \$89 vdd_3v3 50.6495f
Cext_515 \$89 vin 474.156a
Cext_516 \$89 vss_1v2 2.27644f
Cext_517 \$89 vss_3v3 12.8292f
Cext_518 \$89 sub! 13.1032f
Cext_519 \$90 \$91 11.9807a
Cext_520 \$90 \$92 11.9807a
Cext_521 \$90 \$93 11.9807a
Cext_522 \$90 \$94 60.9483a
Cext_523 \$90 \$95 5.64759f
Cext_524 \$90 \$96 6.98759f
Cext_525 \$90 \$97 15.8486a
Cext_526 \$90 \$98 5.09952f
Cext_527 \$90 \$I80 262.859a
Cext_528 \$90 analog_bus0 25.2463a
Cext_529 \$90 analog_bus1 19.3185a
Cext_530 \$90 analog_bus2 2.82729f
Cext_531 \$90 analog_bus3 3.00773f
Cext_532 \$90 dig_in[10] 1.92472f
Cext_533 \$90 dig_in[11] 23.9614a
Cext_534 \$90 dig_in[12] 23.9614a
Cext_535 \$90 dig_in[13] 23.9614a
Cext_536 \$90 dig_in[14] 23.9614a
Cext_537 \$90 dig_in[15] 23.9614a
Cext_538 \$90 dig_in[16] 11.9807a
Cext_539 \$90 dig_in[17] 11.9807a
Cext_540 \$90 dig_in[18] 11.9807a
Cext_541 \$90 dig_in[19] 14.3547a
Cext_542 \$90 dig_in[20] 14.3547a
Cext_543 \$90 dig_in[21] 12.6887a
Cext_544 \$90 dig_in[22] 70.3399a
Cext_545 \$90 dig_in[23] 3.22734f
Cext_546 \$90 dig_in[4] 26.3354a
Cext_547 \$90 dig_in[5] 23.9614a
Cext_548 \$90 dig_in[6] 23.9614a
Cext_549 \$90 dig_in[7] 23.9614a
Cext_550 \$90 dig_in[8] 23.9614a
Cext_551 \$90 dig_in[9] 23.9614a
Cext_552 \$90 dig_out[0] 45.7503a
Cext_553 \$90 dig_out[10] 45.7503a
Cext_554 \$90 dig_out[11] 45.7503a
Cext_555 \$90 dig_out[1] 45.7503a
Cext_556 \$90 dig_out[2] 45.7503a
Cext_557 \$90 dig_out[3] 45.7503a
Cext_558 \$90 dig_out[4] 45.7503a
Cext_559 \$90 dig_out[5] 45.7503a
Cext_560 \$90 dig_out[6] 45.7503a
Cext_561 \$90 dig_out[7] 45.7503a
Cext_562 \$90 dig_out[8] 45.7503a
Cext_563 \$90 dig_out[9] 50.4983a
Cext_564 \$90 enable 136.984a
Cext_565 \$90 gs 431.727a
Cext_566 \$90 gw 120.817a
Cext_567 \$90 vbias 11.0674f
Cext_568 \$90 vdd_1v2 433.186a
Cext_569 \$90 vdd_3v3 4.18542f
Cext_570 \$90 vss_1v2 1.39246f
Cext_571 \$90 vss_3v3 8.23817f
Cext_572 \$90 sub! 18.8587f
Cext_573 \$91 \$92 7.61977f
Cext_574 \$91 \$93 26.2766a
Cext_575 \$91 \$94 21.4075f
Cext_576 \$91 \$95 14.9193a
Cext_577 \$91 \$96 19.3185a
Cext_578 \$91 \$97 43.9476a
Cext_579 \$91 \$98 1.13002f
Cext_580 \$91 analog_bus1 1.09702f
Cext_581 \$91 analog_bus2 43.0956a
Cext_582 \$91 analog_bus3 42.9194a
Cext_583 \$91 dig_in[0] 11.9807a
Cext_584 \$91 dig_in[10] 17.6816a
Cext_585 \$91 dig_in[11] 16.156a
Cext_586 \$91 dig_in[12] 37.8171a
Cext_587 \$91 dig_in[13] 22.7011a
Cext_588 \$91 dig_in[14] 17.687a
Cext_589 \$91 dig_in[15] 12.8008a
Cext_590 \$91 dig_in[1] 11.9807a
Cext_591 \$91 dig_in[20] 42.9194a
Cext_592 \$91 dig_in[21] 31.2398a
Cext_593 \$91 dig_in[22] 31.2398a
Cext_594 \$91 dig_in[23] 42.006a
Cext_595 \$91 dig_in[2] 11.9807a
Cext_596 \$91 dig_in[3] 11.9807a
Cext_597 \$91 dig_in[4] 65.2726a
Cext_598 \$91 dig_in[5] 65.6007a
Cext_599 \$91 dig_in[6] 63.6341a
Cext_600 \$91 dig_in[7] 63.4936a
Cext_601 \$91 dig_in[8] 12.61a
Cext_602 \$91 dig_in[9] 7.59719f
Cext_603 \$91 dig_out[0] 31.2398a
Cext_604 \$91 dig_out[10] 31.2398a
Cext_605 \$91 dig_out[11] 31.2398a
Cext_606 \$91 dig_out[1] 31.2398a
Cext_607 \$91 dig_out[2] 31.2398a
Cext_608 \$91 dig_out[3] 31.2398a
Cext_609 \$91 dig_out[4] 31.2398a
Cext_610 \$91 dig_out[5] 31.2398a
Cext_611 \$91 dig_out[6] 31.2398a
Cext_612 \$91 dig_out[7] 31.3545a
Cext_613 \$91 dig_out[8] 31.4035a
Cext_614 \$91 dig_out[9] 31.4899a
Cext_615 \$91 enable 42.006a
Cext_616 \$91 gw 0.129604a
Cext_617 \$91 rst 233.041a
Cext_618 \$91 s0 30.487a
Cext_619 \$91 s1 49.1341a
Cext_620 \$91 s2 266.49a
Cext_621 \$91 s3 166.535a
Cext_622 \$91 slow 99.5597a
Cext_623 \$91 vbias 31.6583a
Cext_624 \$91 vdd_1v2 325.967a
Cext_625 \$91 vdd_3v3 12.8154f
Cext_626 \$91 vin 284.187a
Cext_627 \$91 vss_1v2 346.988a
Cext_628 \$91 vss_3v3 5.76346f
Cext_629 \$91 sub! 10.1755f
Cext_630 \$92 \$93 11.0459f
Cext_631 \$92 \$94 12.8437a
Cext_632 \$92 \$95 21.3875f
Cext_633 \$92 \$96 23.7941a
Cext_634 \$92 dig_in[0] 11.9807a
Cext_635 \$92 dig_in[10] 71.4069a
Cext_636 \$92 dig_in[11] 67.3827a
Cext_637 \$92 dig_in[12] 37.8171a
Cext_638 \$92 dig_in[13] 22.7011a
Cext_639 \$92 dig_in[14] 17.687a
Cext_640 \$92 dig_in[15] 18.6634a
Cext_641 \$92 dig_in[1] 11.9807a
Cext_642 \$92 dig_in[2] 11.9807a
Cext_643 \$92 dig_in[3] 11.9807a
Cext_644 \$92 dig_in[4] 14.9193a
Cext_645 \$92 dig_in[5] 15.0296a
Cext_646 \$92 dig_in[6] 15.0819a
Cext_647 \$92 dig_in[7] 15.1787a
Cext_648 \$92 dig_in[8] 71.6454a
Cext_649 \$92 dig_in[9] 1.39368f
Cext_650 \$92 dig_out[8] 0.114671a
Cext_651 \$92 dig_out[9] 0.163712a
Cext_652 \$92 rst 254.534a
Cext_653 \$92 s0 30.487a
Cext_654 \$92 s1 49.1341a
Cext_655 \$92 s2 266.49a
Cext_656 \$92 s3 166.535a
Cext_657 \$92 slow 99.7524a
Cext_658 \$92 vbias 0.25014a
Cext_659 \$92 vdd_3v3 3.53729f
Cext_660 \$92 vin 309.527a
Cext_661 \$92 vss_1v2 105.222a
Cext_662 \$92 vss_3v3 578.836a
Cext_663 \$92 sub! 3.25634f
Cext_664 \$93 \$94 12.7056a
Cext_665 \$93 \$95 15.5744a
Cext_666 \$93 \$96 21.3995f
Cext_667 \$93 dig_in[0] 11.9807a
Cext_668 \$93 dig_in[10] 23.2673a
Cext_669 \$93 dig_in[11] 23.2673a
Cext_670 \$93 dig_in[12] 97.0215a
Cext_671 \$93 dig_in[13] 76.1888a
Cext_672 \$93 dig_in[14] 69.1384a
Cext_673 \$93 dig_in[15] 309.608a
Cext_674 \$93 dig_in[1] 11.9807a
Cext_675 \$93 dig_in[2] 11.9807a
Cext_676 \$93 dig_in[3] 11.9807a
Cext_677 \$93 dig_in[4] 14.9193a
Cext_678 \$93 dig_in[5] 14.9193a
Cext_679 \$93 dig_in[6] 15.0296a
Cext_680 \$93 dig_in[7] 15.0819a
Cext_681 \$93 dig_in[8] 21.1914a
Cext_682 \$93 dig_in[9] 49.8755a
Cext_683 \$93 dig_out[9] 0.114671a
Cext_684 \$93 rst 285.99a
Cext_685 \$93 s0 30.487a
Cext_686 \$93 s1 49.1341a
Cext_687 \$93 s2 266.49a
Cext_688 \$93 s3 166.535a
Cext_689 \$93 slow 99.7524a
Cext_690 \$93 vbias 0.163712a
Cext_691 \$93 vdd_3v3 3.86512f
Cext_692 \$93 vin 364.839a
Cext_693 \$93 vss_1v2 105.044a
Cext_694 \$93 vss_3v3 611.502a
Cext_695 \$93 sub! 3.93644f
Cext_696 \$94 \$95 33.6215f
Cext_697 \$94 \$96 23.2984a
Cext_698 \$94 \$97 13.009f
Cext_699 \$94 \$98 71.1978a
Cext_700 \$94 analog_bus0 25.6043a
Cext_701 \$94 analog_bus1 19.3185a
Cext_702 \$94 analog_bus2 44.5648a
Cext_703 \$94 analog_bus3 50.3917a
Cext_704 \$94 bs 47.0192a
Cext_705 \$94 bw 98.4947a
Cext_706 \$94 dig_in[0] 11.9807a
Cext_707 \$94 dig_in[10] 30.5774a
Cext_708 \$94 dig_in[11] 40.6951a
Cext_709 \$94 dig_in[12] 16.6745a
Cext_710 \$94 dig_in[13] 12.1379a
Cext_711 \$94 dig_in[14] 12.1251a
Cext_712 \$94 dig_in[15] 13.8714a
Cext_713 \$94 dig_in[16] 12.7898f
Cext_714 \$94 dig_in[17] 88.364a
Cext_715 \$94 dig_in[18] 25.4121a
Cext_716 \$94 dig_in[19] 24.694a
Cext_717 \$94 dig_in[1] 11.9807a
Cext_718 \$94 dig_in[20] 1.93533f
Cext_719 \$94 dig_in[21] 507.127a
Cext_720 \$94 dig_in[22] 44.5519a
Cext_721 \$94 dig_in[23] 49.4031a
Cext_722 \$94 dig_in[2] 11.9807a
Cext_723 \$94 dig_in[3] 11.9807a
Cext_724 \$94 dig_in[4] 126.579a
Cext_725 \$94 dig_in[5] 115.065a
Cext_726 \$94 dig_in[6] 109.125a
Cext_727 \$94 dig_in[7] 111.086a
Cext_728 \$94 dig_in[8] 13.1888a
Cext_729 \$94 dig_in[9] 13.0039a
Cext_730 \$94 dig_out[0] 38.6369a
Cext_731 \$94 dig_out[10] 38.6369a
Cext_732 \$94 dig_out[11] 38.6369a
Cext_733 \$94 dig_out[1] 38.6369a
Cext_734 \$94 dig_out[2] 38.6369a
Cext_735 \$94 dig_out[3] 38.6369a
Cext_736 \$94 dig_out[4] 38.6369a
Cext_737 \$94 dig_out[5] 38.6369a
Cext_738 \$94 dig_out[6] 38.6369a
Cext_739 \$94 dig_out[7] 38.6369a
Cext_740 \$94 dig_out[8] 38.6369a
Cext_741 \$94 dig_out[9] 41.0109a
Cext_742 \$94 enable 49.4031a
Cext_743 \$94 gs 197.147a
Cext_744 \$94 gw 229.571a
Cext_745 \$94 rst 1.70122f
Cext_746 \$94 s0 115.017a
Cext_747 \$94 s1 176.72a
Cext_748 \$94 s2 110.597a
Cext_749 \$94 s3 166.535a
Cext_750 \$94 slow 1.2046f
Cext_751 \$94 vbias 1.51814f
Cext_752 \$94 vdd_1v2 443.171a
Cext_753 \$94 vdd_3v3 52.3508f
Cext_754 \$94 vin 492.354a
Cext_755 \$94 vss_1v2 3.08244f
Cext_756 \$94 vss_3v3 1.1781f
Cext_757 \$94 sub! 15.1465f
Cext_758 \$95 \$96 45.2821f
Cext_759 \$95 \$97 0.229343a
Cext_760 \$95 \$98 0.327423a
Cext_761 \$95 analog_bus2 539.184a
Cext_762 \$95 analog_bus3 35.8444a
Cext_763 \$95 dig_in[0] 11.9807a
Cext_764 \$95 dig_in[10] 126.519a
Cext_765 \$95 dig_in[11] 135.161a
Cext_766 \$95 dig_in[12] 16.6745a
Cext_767 \$95 dig_in[13] 12.1379a
Cext_768 \$95 dig_in[14] 12.1251a
Cext_769 \$95 dig_in[15] 32.293a
Cext_770 \$95 dig_in[1] 11.9807a
Cext_771 \$95 dig_in[2] 11.9807a
Cext_772 \$95 dig_in[3] 11.9807a
Cext_773 \$95 dig_in[4] 14.9193a
Cext_774 \$95 dig_in[5] 14.9193a
Cext_775 \$95 dig_in[6] 14.9193a
Cext_776 \$95 dig_in[7] 14.9193a
Cext_777 \$95 dig_in[8] 115.22a
Cext_778 \$95 dig_in[9] 107.287a
Cext_779 \$95 dig_out[0] 11.9807a
Cext_780 \$95 dig_out[10] 11.9807a
Cext_781 \$95 dig_out[11] 11.9807a
Cext_782 \$95 dig_out[1] 11.9807a
Cext_783 \$95 dig_out[2] 11.9807a
Cext_784 \$95 dig_out[3] 11.9807a
Cext_785 \$95 dig_out[4] 11.9807a
Cext_786 \$95 dig_out[5] 11.9807a
Cext_787 \$95 dig_out[6] 11.9807a
Cext_788 \$95 dig_out[7] 11.9807a
Cext_789 \$95 dig_out[8] 11.9807a
Cext_790 \$95 dig_out[9] 14.3547a
Cext_791 \$95 enable 17.9086a
Cext_792 \$95 gs 3.45818a
Cext_793 \$95 rst 1.72237f
Cext_794 \$95 s0 115.017a
Cext_795 \$95 s1 176.72a
Cext_796 \$95 s2 110.597a
Cext_797 \$95 s3 166.535a
Cext_798 \$95 slow 1.20508f
Cext_799 \$95 vdd_1v2 105.863a
Cext_800 \$95 vdd_3v3 52.0584f
Cext_801 \$95 vin 518.714a
Cext_802 \$95 vss_1v2 3.57505f
Cext_803 \$95 vss_3v3 1.50289f
Cext_804 \$95 sub! 11.4327f
Cext_805 \$96 \$98 0.229343a
Cext_806 \$96 \$I52 5.38639a
Cext_807 \$96 analog_bus2 365.617a
Cext_808 \$96 analog_bus3 567.09a
Cext_809 \$96 dig_in[0] 19.3185a
Cext_810 \$96 dig_in[10] 23.7941a
Cext_811 \$96 dig_in[11] 23.7941a
Cext_812 \$96 dig_in[12] 126.051a
Cext_813 \$96 dig_in[13] 103.566a
Cext_814 \$96 dig_in[14] 103.641a
Cext_815 \$96 dig_in[15] 128.161a
Cext_816 \$96 dig_in[1] 19.3185a
Cext_817 \$96 dig_in[22] 1.91013f
Cext_818 \$96 dig_in[23] 488.198a
Cext_819 \$96 dig_in[2] 19.3185a
Cext_820 \$96 dig_in[3] 19.3185a
Cext_821 \$96 dig_in[4] 19.3185a
Cext_822 \$96 dig_in[5] 19.3185a
Cext_823 \$96 dig_in[6] 19.3185a
Cext_824 \$96 dig_in[7] 19.3185a
Cext_825 \$96 dig_in[8] 23.7941a
Cext_826 \$96 dig_in[9] 23.7941a
Cext_827 \$96 dig_out[0] 38.6369a
Cext_828 \$96 dig_out[10] 38.6369a
Cext_829 \$96 dig_out[11] 38.6369a
Cext_830 \$96 dig_out[1] 38.6369a
Cext_831 \$96 dig_out[2] 38.6369a
Cext_832 \$96 dig_out[3] 38.6369a
Cext_833 \$96 dig_out[4] 38.6369a
Cext_834 \$96 dig_out[5] 38.6369a
Cext_835 \$96 dig_out[6] 38.6369a
Cext_836 \$96 dig_out[7] 38.6369a
Cext_837 \$96 dig_out[8] 38.6369a
Cext_838 \$96 dig_out[9] 43.3849a
Cext_839 \$96 enable 50.4927a
Cext_840 \$96 gs 88.9299a
Cext_841 \$96 gw 90.7303a
Cext_842 \$96 rst 1.76351f
Cext_843 \$96 s0 115.017a
Cext_844 \$96 s1 176.72a
Cext_845 \$96 s2 110.597a
Cext_846 \$96 s3 166.535a
Cext_847 \$96 slow 1.20508f
Cext_848 \$96 vdd_1v2 443.297a
Cext_849 \$96 vdd_3v3 52.7593f
Cext_850 \$96 vin 652.319a
Cext_851 \$96 vss_1v2 8.20307f
Cext_852 \$96 vss_3v3 1.44154f
Cext_853 \$96 sub! 29.7635f
Cext_854 \$97 \$98 14.4578f
Cext_855 \$97 analog_bus0 17.9086a
Cext_856 \$97 analog_bus1 12.9606a
Cext_857 \$97 analog_bus2 37.1677a
Cext_858 \$97 analog_bus3 42.9194a
Cext_859 \$97 bs 417.462a
Cext_860 \$97 bw 466.537a
Cext_861 \$97 dig_in[16] 70.906a
Cext_862 \$97 dig_in[17] 97.9228a
Cext_863 \$97 dig_in[18] 22.824a
Cext_864 \$97 dig_in[19] 1.65728f
Cext_865 \$97 dig_in[20] 45.8581a
Cext_866 \$97 dig_in[21] 34.1784a
Cext_867 \$97 dig_in[22] 34.1784a
Cext_868 \$97 dig_in[23] 44.9447a
Cext_869 \$97 dig_out[0] 34.1784a
Cext_870 \$97 dig_out[10] 34.1784a
Cext_871 \$97 dig_out[11] 34.1784a
Cext_872 \$97 dig_out[1] 34.1784a
Cext_873 \$97 dig_out[2] 34.1784a
Cext_874 \$97 dig_out[3] 34.1784a
Cext_875 \$97 dig_out[4] 34.1784a
Cext_876 \$97 dig_out[5] 34.1784a
Cext_877 \$97 dig_out[6] 34.1784a
Cext_878 \$97 dig_out[7] 34.1784a
Cext_879 \$97 dig_out[8] 34.1784a
Cext_880 \$97 dig_out[9] 34.1784a
Cext_881 \$97 enable 44.9447a
Cext_882 \$97 gs 329.885a
Cext_883 \$97 gw 484.773a
Cext_884 \$97 vbias 34.1784a
Cext_885 \$97 vdd_1v2 325.967a
Cext_886 \$97 vdd_3v3 23.7233f
Cext_887 \$97 vss_1v2 346.88a
Cext_888 \$97 vss_3v3 1.12856f
Cext_889 \$97 sub! 5.09265f
Cext_890 \$98 \$I80 0.599677a
Cext_891 \$98 analog_bus0 17.9086a
Cext_892 \$98 analog_bus1 11.9807a
Cext_893 \$98 analog_bus2 37.227a
Cext_894 \$98 analog_bus3 42.9788a
Cext_895 \$98 bs 417.343a
Cext_896 \$98 bw 430.331a
Cext_897 \$98 dig_in[16] 11.9807a
Cext_898 \$98 dig_in[17] 12.2609a
Cext_899 \$98 dig_in[18] 65.6726a
Cext_900 \$98 dig_in[19] 79.1261a
Cext_901 \$98 dig_in[20] 42.9788a
Cext_902 \$98 dig_in[21] 31.2992a
Cext_903 \$98 dig_in[22] 31.2992a
Cext_904 \$98 dig_in[23] 42.0654a
Cext_905 \$98 dig_out[0] 31.2992a
Cext_906 \$98 dig_out[10] 31.2992a
Cext_907 \$98 dig_out[11] 31.2992a
Cext_908 \$98 dig_out[1] 31.2992a
Cext_909 \$98 dig_out[2] 31.2992a
Cext_910 \$98 dig_out[3] 31.2992a
Cext_911 \$98 dig_out[4] 31.2992a
Cext_912 \$98 dig_out[5] 31.2992a
Cext_913 \$98 dig_out[6] 31.2992a
Cext_914 \$98 dig_out[7] 31.2992a
Cext_915 \$98 dig_out[8] 31.2992a
Cext_916 \$98 dig_out[9] 31.2992a
Cext_917 \$98 enable 42.0654a
Cext_918 \$98 gs 329.885a
Cext_919 \$98 gw 466.591a
Cext_920 \$98 vbias 31.2992a
Cext_921 \$98 vdd_1v2 334.309a
Cext_922 \$98 vdd_3v3 22.6117f
Cext_923 \$98 vss_1v2 432.782a
Cext_924 \$98 vss_3v3 955.937a
Cext_925 \$98 sub! 5.79294f
Cext_926 \$I52 analog_bus3 2.07974a
Cext_927 \$I52 dig_out[10] 1.89499a
Cext_928 \$I52 dig_out[11] 0.757994a
Cext_929 \$I52 dig_out[3] 1.76216a
Cext_930 \$I52 dig_out[4] 1.76216a
Cext_931 \$I52 dig_out[5] 1.7169a
Cext_932 \$I52 dig_out[6] 1.79894a
Cext_933 \$I52 dig_out[7] 1.89499a
Cext_934 \$I52 dig_out[8] 1.80865a
Cext_935 \$I52 dig_out[9] 0.416754a
Cext_936 \$I52 enable 175.137a
Cext_937 \$I52 vdd_1v2 492.419a
Cext_938 \$I52 vss_1v2 102.448a
Cext_939 \$I52 vss_3v3 74.0778a
Cext_940 \$I80 dig_in[18] 0.599677a
Cext_941 \$I80 dig_in[19] 0.599677a
Cext_942 \$I80 enable 93.8793a
Cext_943 \$I80 vbias 117.918a
Cext_944 \$I80 vdd_1v2 1.86271f
Cext_945 \$I80 vdd_3v3 10.7435f
Cext_946 \$I80 vss_3v3 101.943a
Cext_947 analog_bus0 analog_bus1 33.59f
Cext_948 analog_bus0 analog_bus2 61.7448a
Cext_949 analog_bus0 analog_bus3 61.7734a
Cext_950 analog_bus0 clk 2.32965a
Cext_951 analog_bus0 dig_in[0] 23.3245a
Cext_952 analog_bus0 dig_in[10] 19.1224a
Cext_953 analog_bus0 dig_in[11] 18.893a
Cext_954 analog_bus0 dig_in[12] 18.893a
Cext_955 analog_bus0 dig_in[13] 18.893a
Cext_956 analog_bus0 dig_in[14] 18.893a
Cext_957 analog_bus0 dig_in[15] 18.893a
Cext_958 analog_bus0 dig_in[16] 36.8016a
Cext_959 analog_bus0 dig_in[17] 36.8016a
Cext_960 analog_bus0 dig_in[18] 36.8016a
Cext_961 analog_bus0 dig_in[19] 36.8016a
Cext_962 analog_bus0 dig_in[1] 19.3527a
Cext_963 analog_bus0 dig_in[20] 18.893a
Cext_964 analog_bus0 dig_in[21] 18.893a
Cext_965 analog_bus0 dig_in[22] 18.893a
Cext_966 analog_bus0 dig_in[23] 21.3063a
Cext_967 analog_bus0 dig_in[2] 18.893a
Cext_968 analog_bus0 dig_in[3] 18.893a
Cext_969 analog_bus0 dig_in[4] 18.893a
Cext_970 analog_bus0 dig_in[5] 18.893a
Cext_971 analog_bus0 dig_in[6] 18.893a
Cext_972 analog_bus0 dig_in[7] 18.893a
Cext_973 analog_bus0 dig_in[8] 18.893a
Cext_974 analog_bus0 dig_in[9] 18.893a
Cext_975 analog_bus0 dig_out[0] 25.3397a
Cext_976 analog_bus0 dig_out[10] 18.893a
Cext_977 analog_bus0 dig_out[11] 22.6221a
Cext_978 analog_bus0 dig_out[1] 18.893a
Cext_979 analog_bus0 dig_out[2] 18.893a
Cext_980 analog_bus0 dig_out[3] 18.893a
Cext_981 analog_bus0 dig_out[4] 18.893a
Cext_982 analog_bus0 dig_out[5] 18.893a
Cext_983 analog_bus0 dig_out[6] 18.893a
Cext_984 analog_bus0 dig_out[7] 18.893a
Cext_985 analog_bus0 dig_out[8] 18.893a
Cext_986 analog_bus0 dig_out[9] 18.893a
Cext_987 analog_bus0 enable 57.2404a
Cext_988 analog_bus0 ibias0 21.1786a
Cext_989 analog_bus0 ibias1 21.1786a
Cext_990 analog_bus0 reset 2.32965a
Cext_991 analog_bus0 vbias 83.7885a
Cext_992 analog_bus0 vdd_1v2 7.24655f
Cext_993 analog_bus0 vdd_3v3 3.23965f
Cext_994 analog_bus0 vss_1v2 501.438a
Cext_995 analog_bus0 vss_3v3 2.77586f
Cext_996 analog_bus1 analog_bus2 33.9121f
Cext_997 analog_bus1 analog_bus3 34.2296a
Cext_998 analog_bus1 clk 0.194958a
Cext_999 analog_bus1 dig_in[0] 16.6303a
Cext_1000 analog_bus1 dig_in[10] 12.1857a
Cext_1001 analog_bus1 dig_in[11] 11.9554a
Cext_1002 analog_bus1 dig_in[12] 11.726a
Cext_1003 analog_bus1 dig_in[13] 11.726a
Cext_1004 analog_bus1 dig_in[14] 11.726a
Cext_1005 analog_bus1 dig_in[15] 11.726a
Cext_1006 analog_bus1 dig_in[16] 23.7067a
Cext_1007 analog_bus1 dig_in[17] 23.7067a
Cext_1008 analog_bus1 dig_in[18] 23.7067a
Cext_1009 analog_bus1 dig_in[19] 23.7067a
Cext_1010 analog_bus1 dig_in[1] 12.4284a
Cext_1011 analog_bus1 dig_in[20] 11.726a
Cext_1012 analog_bus1 dig_in[21] 11.726a
Cext_1013 analog_bus1 dig_in[22] 11.726a
Cext_1014 analog_bus1 dig_in[23] 14.1394a
Cext_1015 analog_bus1 dig_in[2] 11.726a
Cext_1016 analog_bus1 dig_in[3] 11.726a
Cext_1017 analog_bus1 dig_in[4] 11.726a
Cext_1018 analog_bus1 dig_in[5] 11.726a
Cext_1019 analog_bus1 dig_in[6] 11.726a
Cext_1020 analog_bus1 dig_in[7] 11.726a
Cext_1021 analog_bus1 dig_in[8] 11.726a
Cext_1022 analog_bus1 dig_in[9] 11.726a
Cext_1023 analog_bus1 dig_out[0] 18.1727a
Cext_1024 analog_bus1 dig_out[10] 11.726a
Cext_1025 analog_bus1 dig_out[11] 15.4551a
Cext_1026 analog_bus1 dig_out[1] 11.726a
Cext_1027 analog_bus1 dig_out[2] 11.726a
Cext_1028 analog_bus1 dig_out[3] 11.726a
Cext_1029 analog_bus1 dig_out[4] 11.726a
Cext_1030 analog_bus1 dig_out[5] 11.726a
Cext_1031 analog_bus1 dig_out[6] 11.726a
Cext_1032 analog_bus1 dig_out[7] 11.726a
Cext_1033 analog_bus1 dig_out[8] 11.726a
Cext_1034 analog_bus1 dig_out[9] 11.726a
Cext_1035 analog_bus1 enable 44.1455a
Cext_1036 analog_bus1 ibias0 1.77234a
Cext_1037 analog_bus1 ibias1 1.77234a
Cext_1038 analog_bus1 reset 0.194958a
Cext_1039 analog_bus1 vbias 49.3047a
Cext_1040 analog_bus1 vdd_1v2 1.17204f
Cext_1041 analog_bus1 vdd_3v3 3.17595f
Cext_1042 analog_bus1 vss_1v2 149.117a
Cext_1043 analog_bus1 vss_3v3 2.76817f
Cext_1044 analog_bus2 analog_bus3 41.713f
Cext_1045 analog_bus2 clk 0.130411a
Cext_1046 analog_bus2 dig_in[0] 17.6424a
Cext_1047 analog_bus2 dig_in[10] 12.4284a
Cext_1048 analog_bus2 dig_in[11] 12.1857a
Cext_1049 analog_bus2 dig_in[12] 11.9554a
Cext_1050 analog_bus2 dig_in[13] 11.726a
Cext_1051 analog_bus2 dig_in[14] 11.726a
Cext_1052 analog_bus2 dig_in[15] 11.726a
Cext_1053 analog_bus2 dig_in[16] 23.7067a
Cext_1054 analog_bus2 dig_in[17] 23.7067a
Cext_1055 analog_bus2 dig_in[18] 23.7067a
Cext_1056 analog_bus2 dig_in[19] 23.7067a
Cext_1057 analog_bus2 dig_in[1] 12.9012a
Cext_1058 analog_bus2 dig_in[20] 29.6346a
Cext_1059 analog_bus2 dig_in[21] 29.6346a
Cext_1060 analog_bus2 dig_in[22] 2.5369f
Cext_1061 analog_bus2 dig_in[23] 62.2996a
Cext_1062 analog_bus2 dig_in[2] 11.726a
Cext_1063 analog_bus2 dig_in[3] 11.726a
Cext_1064 analog_bus2 dig_in[4] 11.726a
Cext_1065 analog_bus2 dig_in[5] 11.726a
Cext_1066 analog_bus2 dig_in[6] 11.726a
Cext_1067 analog_bus2 dig_in[7] 11.726a
Cext_1068 analog_bus2 dig_in[8] 11.726a
Cext_1069 analog_bus2 dig_in[9] 11.726a
Cext_1070 analog_bus2 dig_out[0] 18.1727a
Cext_1071 analog_bus2 dig_out[10] 11.726a
Cext_1072 analog_bus2 dig_out[11] 15.4551a
Cext_1073 analog_bus2 dig_out[1] 11.726a
Cext_1074 analog_bus2 dig_out[2] 11.726a
Cext_1075 analog_bus2 dig_out[3] 11.726a
Cext_1076 analog_bus2 dig_out[4] 11.726a
Cext_1077 analog_bus2 dig_out[5] 11.726a
Cext_1078 analog_bus2 dig_out[6] 11.726a
Cext_1079 analog_bus2 dig_out[7] 11.726a
Cext_1080 analog_bus2 dig_out[8] 11.726a
Cext_1081 analog_bus2 dig_out[9] 11.726a
Cext_1082 analog_bus2 enable 44.1455a
Cext_1083 analog_bus2 gs 78.3585a
Cext_1084 analog_bus2 gw 39.7867a
Cext_1085 analog_bus2 ibias0 1.18555a
Cext_1086 analog_bus2 ibias1 1.18555a
Cext_1087 analog_bus2 reset 0.130411a
Cext_1088 analog_bus2 vbias 66.7439a
Cext_1089 analog_bus2 vdd_1v2 1.97326f
Cext_1090 analog_bus2 vdd_3v3 120.434a
Cext_1091 analog_bus2 vss_1v2 136.302a
Cext_1092 analog_bus2 vss_3v3 6.96105f
Cext_1093 analog_bus3 dig_in[0] 5.98691f
Cext_1094 analog_bus3 dig_in[10] 175.589a
Cext_1095 analog_bus3 dig_in[11] 29.7013a
Cext_1096 analog_bus3 dig_in[12] 27.5409a
Cext_1097 analog_bus3 dig_in[13] 26.1009a
Cext_1098 analog_bus3 dig_in[14] 25.0381a
Cext_1099 analog_bus3 dig_in[15] 24.4287a
Cext_1100 analog_bus3 dig_in[16] 687.878a
Cext_1101 analog_bus3 dig_in[17] 41.1745a
Cext_1102 analog_bus3 dig_in[18] 42.7477a
Cext_1103 analog_bus3 dig_in[19] 42.4112a
Cext_1104 analog_bus3 dig_in[1] 43.3307a
Cext_1105 analog_bus3 dig_in[20] 637.334a
Cext_1106 analog_bus3 dig_in[21] 40.383a
Cext_1107 analog_bus3 dig_in[22] 100.314a
Cext_1108 analog_bus3 dig_in[23] 40.1195a
Cext_1109 analog_bus3 dig_in[2] 16.6493a
Cext_1110 analog_bus3 dig_in[3] 16.6493a
Cext_1111 analog_bus3 dig_in[4] 16.6493a
Cext_1112 analog_bus3 dig_in[5] 16.6493a
Cext_1113 analog_bus3 dig_in[6] 16.6493a
Cext_1114 analog_bus3 dig_in[7] 16.6493a
Cext_1115 analog_bus3 dig_in[8] 16.6493a
Cext_1116 analog_bus3 dig_in[9] 16.6493a
Cext_1117 analog_bus3 dig_out[0] 18.1727a
Cext_1118 analog_bus3 dig_out[10] 11.726a
Cext_1119 analog_bus3 dig_out[11] 15.4551a
Cext_1120 analog_bus3 dig_out[1] 11.726a
Cext_1121 analog_bus3 dig_out[2] 11.726a
Cext_1122 analog_bus3 dig_out[3] 11.726a
Cext_1123 analog_bus3 dig_out[4] 11.726a
Cext_1124 analog_bus3 dig_out[5] 11.726a
Cext_1125 analog_bus3 dig_out[6] 11.726a
Cext_1126 analog_bus3 dig_out[7] 11.726a
Cext_1127 analog_bus3 dig_out[8] 11.726a
Cext_1128 analog_bus3 dig_out[9] 11.726a
Cext_1129 analog_bus3 enable 52.2171a
Cext_1130 analog_bus3 gs 0.149028a
Cext_1131 analog_bus3 ibias0 0.843986a
Cext_1132 analog_bus3 ibias1 0.843986a
Cext_1133 analog_bus3 vbias 84.7489a
Cext_1134 analog_bus3 vdd_1v2 919.403a
Cext_1135 analog_bus3 vdd_3v3 138.728a
Cext_1136 analog_bus3 vss_1v2 132.314a
Cext_1137 analog_bus3 vss_3v3 319.415a
Cext_1138 bs bw 296.583a
Cext_1139 bs dig_in[16] 34.0351a
Cext_1140 bs dig_in[17] 590.162a
Cext_1141 bs dig_in[18] 34.0351a
Cext_1142 bs dig_in[19] 590.162a
Cext_1143 bs gs 564.615a
Cext_1144 bs gw 536.248a
Cext_1145 bs vdd_1v2 1.53252a
Cext_1146 bs vdd_3v3 63.603a
Cext_1147 bs vss_3v3 234.972a
Cext_1148 bw dig_in[16] 530.456a
Cext_1149 bw dig_in[17] 34.586a
Cext_1150 bw dig_in[18] 529.221a
Cext_1151 bw dig_in[19] 33.4592a
Cext_1152 bw gw 704.87a
Cext_1153 bw vdd_1v2 3.01839a
Cext_1154 bw vdd_3v3 615.244a
Cext_1155 bw vss_3v3 231.514a
Cext_1156 clk enable 215.309a
Cext_1157 clk vss_1v2 45.5738a
Cext_1158 dig_in[0] dig_in[10] 29.0005a
Cext_1159 dig_in[0] dig_in[11] 25.09a
Cext_1160 dig_in[0] dig_in[12] 24.584a
Cext_1161 dig_in[0] dig_in[13] 24.4029a
Cext_1162 dig_in[0] dig_in[14] 24.178a
Cext_1163 dig_in[0] dig_in[15] 23.9614a
Cext_1164 dig_in[0] dig_in[16] 11.9807a
Cext_1165 dig_in[0] dig_in[17] 11.9807a
Cext_1166 dig_in[0] dig_in[18] 11.9807a
Cext_1167 dig_in[0] dig_in[19] 11.9807a
Cext_1168 dig_in[0] dig_in[1] 33.2495f
Cext_1169 dig_in[0] dig_in[20] 11.9807a
Cext_1170 dig_in[0] dig_in[21] 11.9807a
Cext_1171 dig_in[0] dig_in[22] 11.9807a
Cext_1172 dig_in[0] dig_in[23] 11.9807a
Cext_1173 dig_in[0] dig_in[2] 40.3166a
Cext_1174 dig_in[0] dig_in[3] 43.726a
Cext_1175 dig_in[0] dig_in[4] 24.2574a
Cext_1176 dig_in[0] dig_in[5] 24.1915a
Cext_1177 dig_in[0] dig_in[6] 24.1235a
Cext_1178 dig_in[0] dig_in[7] 24.0293a
Cext_1179 dig_in[0] dig_in[8] 23.9614a
Cext_1180 dig_in[0] dig_in[9] 23.9614a
Cext_1181 dig_in[0] dig_out[0] 37.4911a
Cext_1182 dig_in[0] dig_out[10] 31.0445a
Cext_1183 dig_in[0] dig_out[11] 135.578a
Cext_1184 dig_in[0] dig_out[1] 31.0445a
Cext_1185 dig_in[0] dig_out[2] 31.0445a
Cext_1186 dig_in[0] dig_out[3] 31.0445a
Cext_1187 dig_in[0] dig_out[4] 31.0445a
Cext_1188 dig_in[0] dig_out[5] 31.0445a
Cext_1189 dig_in[0] dig_out[6] 31.0445a
Cext_1190 dig_in[0] dig_out[7] 31.0445a
Cext_1191 dig_in[0] dig_out[8] 31.0445a
Cext_1192 dig_in[0] dig_out[9] 31.0445a
Cext_1193 dig_in[0] enable 1.03241f
Cext_1194 dig_in[0] rst 44.3868a
Cext_1195 dig_in[0] s0 643.75a
Cext_1196 dig_in[0] s1 51.3775a
Cext_1197 dig_in[0] s2 84.7481a
Cext_1198 dig_in[0] s3 168.111a
Cext_1199 dig_in[0] slow 47.8371a
Cext_1200 dig_in[0] vbias 25.3786a
Cext_1201 dig_in[0] vdd_1v2 76.8575a
Cext_1202 dig_in[0] vdd_3v3 663.925a
Cext_1203 dig_in[0] vin 217.435a
Cext_1204 dig_in[0] vss_1v2 365.033a
Cext_1205 dig_in[0] vss_3v3 1.14229f
Cext_1206 dig_in[10] dig_in[11] 41.0072f
Cext_1207 dig_in[10] dig_in[12] 27.0167a
Cext_1208 dig_in[10] dig_in[13] 25.6593a
Cext_1209 dig_in[10] dig_in[14] 24.9839a
Cext_1210 dig_in[10] dig_in[15] 31.4439a
Cext_1211 dig_in[10] dig_in[16] 12.3593a
Cext_1212 dig_in[10] dig_in[17] 12.1005a
Cext_1213 dig_in[10] dig_in[18] 11.9807a
Cext_1214 dig_in[10] dig_in[19] 14.3547a
Cext_1215 dig_in[10] dig_in[1] 5.91574f
Cext_1216 dig_in[10] dig_in[20] 14.3547a
Cext_1217 dig_in[10] dig_in[21] 11.9807a
Cext_1218 dig_in[10] dig_in[22] 11.9807a
Cext_1219 dig_in[10] dig_in[23] 14.3547a
Cext_1220 dig_in[10] dig_in[2] 36.5713a
Cext_1221 dig_in[10] dig_in[3] 31.5686a
Cext_1222 dig_in[10] dig_in[4] 49.4578a
Cext_1223 dig_in[10] dig_in[5] 47.0838a
Cext_1224 dig_in[10] dig_in[6] 47.0838a
Cext_1225 dig_in[10] dig_in[7] 47.0838a
Cext_1226 dig_in[10] dig_in[8] 62.4323a
Cext_1227 dig_in[10] dig_in[9] 21.7321f
Cext_1228 dig_in[10] dig_out[0] 30.1534a
Cext_1229 dig_in[10] dig_out[10] 23.7067a
Cext_1230 dig_in[10] dig_out[11] 28.7095a
Cext_1231 dig_in[10] dig_out[1] 23.7067a
Cext_1232 dig_in[10] dig_out[2] 23.7067a
Cext_1233 dig_in[10] dig_out[3] 23.7067a
Cext_1234 dig_in[10] dig_out[4] 23.7067a
Cext_1235 dig_in[10] dig_out[5] 23.7067a
Cext_1236 dig_in[10] dig_out[6] 23.7067a
Cext_1237 dig_in[10] dig_out[7] 23.7067a
Cext_1238 dig_in[10] dig_out[8] 23.7067a
Cext_1239 dig_in[10] dig_out[9] 23.7067a
Cext_1240 dig_in[10] enable 31.2992a
Cext_1241 dig_in[10] rst 48.8223a
Cext_1242 dig_in[10] s0 36.5548a
Cext_1243 dig_in[10] s1 55.9195a
Cext_1244 dig_in[10] s2 948.685a
Cext_1245 dig_in[10] s3 168.111a
Cext_1246 dig_in[10] slow 46.9449a
Cext_1247 dig_in[10] vbias 32.0528a
Cext_1248 dig_in[10] vdd_1v2 53.3394a
Cext_1249 dig_in[10] vdd_3v3 4.76205f
Cext_1250 dig_in[10] vin 280.904a
Cext_1251 dig_in[10] vss_1v2 268.468a
Cext_1252 dig_in[10] vss_3v3 1.25643f
Cext_1253 dig_in[11] dig_in[12] 20.0864f
Cext_1254 dig_in[11] dig_in[13] 27.0686a
Cext_1255 dig_in[11] dig_in[14] 25.6593a
Cext_1256 dig_in[11] dig_in[15] 31.7948a
Cext_1257 dig_in[11] dig_in[16] 12.6523a
Cext_1258 dig_in[11] dig_in[17] 12.3593a
Cext_1259 dig_in[11] dig_in[18] 12.1005a
Cext_1260 dig_in[11] dig_in[19] 14.3547a
Cext_1261 dig_in[11] dig_in[1] 26.0619a
Cext_1262 dig_in[11] dig_in[20] 14.3547a
Cext_1263 dig_in[11] dig_in[21] 11.9807a
Cext_1264 dig_in[11] dig_in[22] 11.9807a
Cext_1265 dig_in[11] dig_in[23] 14.3547a
Cext_1266 dig_in[11] dig_in[2] 28.7095a
Cext_1267 dig_in[11] dig_in[3] 23.7067a
Cext_1268 dig_in[11] dig_in[4] 38.0614a
Cext_1269 dig_in[11] dig_in[5] 35.6874a
Cext_1270 dig_in[11] dig_in[6] 35.6874a
Cext_1271 dig_in[11] dig_in[7] 35.6874a
Cext_1272 dig_in[11] dig_in[8] 50.407a
Cext_1273 dig_in[11] dig_in[9] 68.7255a
Cext_1274 dig_in[11] dig_out[0] 30.1534a
Cext_1275 dig_in[11] dig_out[10] 23.7067a
Cext_1276 dig_in[11] dig_out[11] 28.7095a
Cext_1277 dig_in[11] dig_out[1] 23.7067a
Cext_1278 dig_in[11] dig_out[2] 23.7067a
Cext_1279 dig_in[11] dig_out[3] 23.7067a
Cext_1280 dig_in[11] dig_out[4] 23.7067a
Cext_1281 dig_in[11] dig_out[5] 23.7067a
Cext_1282 dig_in[11] dig_out[6] 23.7067a
Cext_1283 dig_in[11] dig_out[7] 23.7067a
Cext_1284 dig_in[11] dig_out[8] 23.7067a
Cext_1285 dig_in[11] dig_out[9] 23.7067a
Cext_1286 dig_in[11] enable 31.2992a
Cext_1287 dig_in[11] rst 50.0191a
Cext_1288 dig_in[11] s0 36.5548a
Cext_1289 dig_in[11] s1 55.9195a
Cext_1290 dig_in[11] s2 89.5703a
Cext_1291 dig_in[11] s3 1.43239f
Cext_1292 dig_in[11] slow 46.3857a
Cext_1293 dig_in[11] vbias 28.4371a
Cext_1294 dig_in[11] vdd_1v2 43.4596a
Cext_1295 dig_in[11] vdd_3v3 1.6136f
Cext_1296 dig_in[11] vin 20.1273f
Cext_1297 dig_in[11] vss_1v2 234.229a
Cext_1298 dig_in[11] vss_3v3 875.713a
Cext_1299 dig_in[12] dig_in[13] 44.4465f
Cext_1300 dig_in[12] dig_in[14] 42.4171a
Cext_1301 dig_in[12] dig_in[15] 47.7166a
Cext_1302 dig_in[12] dig_in[16] 13.0032a
Cext_1303 dig_in[12] dig_in[17] 12.6523a
Cext_1304 dig_in[12] dig_in[18] 12.3593a
Cext_1305 dig_in[12] dig_in[19] 14.4745a
Cext_1306 dig_in[12] dig_in[1] 25.0381a
Cext_1307 dig_in[12] dig_in[20] 14.3547a
Cext_1308 dig_in[12] dig_in[21] 11.9807a
Cext_1309 dig_in[12] dig_in[22] 11.9807a
Cext_1310 dig_in[12] dig_in[23] 14.3547a
Cext_1311 dig_in[12] dig_in[2] 28.6576a
Cext_1312 dig_in[12] dig_in[3] 23.6548a
Cext_1313 dig_in[12] dig_in[4] 38.0095a
Cext_1314 dig_in[12] dig_in[5] 35.6355a
Cext_1315 dig_in[12] dig_in[6] 35.6355a
Cext_1316 dig_in[12] dig_in[7] 35.6355a
Cext_1317 dig_in[12] dig_in[8] 35.6355a
Cext_1318 dig_in[12] dig_in[9] 48.2933a
Cext_1319 dig_in[12] dig_out[0] 30.1534a
Cext_1320 dig_in[12] dig_out[10] 23.7067a
Cext_1321 dig_in[12] dig_out[11] 28.7095a
Cext_1322 dig_in[12] dig_out[1] 23.7067a
Cext_1323 dig_in[12] dig_out[2] 23.7067a
Cext_1324 dig_in[12] dig_out[3] 23.7067a
Cext_1325 dig_in[12] dig_out[4] 23.7067a
Cext_1326 dig_in[12] dig_out[5] 23.7067a
Cext_1327 dig_in[12] dig_out[6] 23.7067a
Cext_1328 dig_in[12] dig_out[7] 23.7067a
Cext_1329 dig_in[12] dig_out[8] 23.7067a
Cext_1330 dig_in[12] dig_out[9] 23.7067a
Cext_1331 dig_in[12] enable 31.2992a
Cext_1332 dig_in[12] rst 52.8204a
Cext_1333 dig_in[12] s0 643.75a
Cext_1334 dig_in[12] s1 51.3775a
Cext_1335 dig_in[12] s2 84.7481a
Cext_1336 dig_in[12] s3 168.111a
Cext_1337 dig_in[12] slow 48.0063a
Cext_1338 dig_in[12] vbias 28.4371a
Cext_1339 dig_in[12] vdd_1v2 36.17a
Cext_1340 dig_in[12] vdd_3v3 3.37324f
Cext_1341 dig_in[12] vin 336.387a
Cext_1342 dig_in[12] vss_1v2 234.371a
Cext_1343 dig_in[12] vss_3v3 964.787a
Cext_1344 dig_in[13] dig_in[14] 44.4938f
Cext_1345 dig_in[13] dig_in[15] 49.7549a
Cext_1346 dig_in[13] dig_in[16] 13.6786a
Cext_1347 dig_in[13] dig_in[17] 13.0032a
Cext_1348 dig_in[13] dig_in[18] 12.6523a
Cext_1349 dig_in[13] dig_in[19] 14.7333a
Cext_1350 dig_in[13] dig_in[1] 24.6359a
Cext_1351 dig_in[13] dig_in[20] 14.4745a
Cext_1352 dig_in[13] dig_in[21] 11.9807a
Cext_1353 dig_in[13] dig_in[22] 11.9807a
Cext_1354 dig_in[13] dig_in[23] 14.3547a
Cext_1355 dig_in[13] dig_in[2] 28.7095a
Cext_1356 dig_in[13] dig_in[3] 23.7067a
Cext_1357 dig_in[13] dig_in[4] 38.0614a
Cext_1358 dig_in[13] dig_in[5] 35.6874a
Cext_1359 dig_in[13] dig_in[6] 35.6874a
Cext_1360 dig_in[13] dig_in[7] 35.6874a
Cext_1361 dig_in[13] dig_in[8] 35.6874a
Cext_1362 dig_in[13] dig_in[9] 46.5004a
Cext_1363 dig_in[13] dig_out[0] 30.1534a
Cext_1364 dig_in[13] dig_out[10] 23.7067a
Cext_1365 dig_in[13] dig_out[11] 28.7095a
Cext_1366 dig_in[13] dig_out[1] 23.7067a
Cext_1367 dig_in[13] dig_out[2] 23.7067a
Cext_1368 dig_in[13] dig_out[3] 23.7067a
Cext_1369 dig_in[13] dig_out[4] 23.7067a
Cext_1370 dig_in[13] dig_out[5] 23.7067a
Cext_1371 dig_in[13] dig_out[6] 23.7067a
Cext_1372 dig_in[13] dig_out[7] 23.7067a
Cext_1373 dig_in[13] dig_out[8] 23.7067a
Cext_1374 dig_in[13] dig_out[9] 23.7067a
Cext_1375 dig_in[13] enable 31.2992a
Cext_1376 dig_in[13] rst 60.2543a
Cext_1377 dig_in[13] s0 36.5548a
Cext_1378 dig_in[13] s1 745.127a
Cext_1379 dig_in[13] s2 85.6153a
Cext_1380 dig_in[13] s3 168.111a
Cext_1381 dig_in[13] slow 47.4918a
Cext_1382 dig_in[13] vbias 28.4371a
Cext_1383 dig_in[13] vdd_1v2 30.3203a
Cext_1384 dig_in[13] vdd_3v3 2.88759f
Cext_1385 dig_in[13] vin 260.428a
Cext_1386 dig_in[13] vss_1v2 234.507a
Cext_1387 dig_in[13] vss_3v3 749.582a
Cext_1388 dig_in[14] dig_in[15] 44.5501f
Cext_1389 dig_in[14] dig_in[16] 15.0879a
Cext_1390 dig_in[14] dig_in[17] 13.6786a
Cext_1391 dig_in[14] dig_in[18] 13.0032a
Cext_1392 dig_in[14] dig_in[19] 15.0263a
Cext_1393 dig_in[14] dig_in[1] 24.4029a
Cext_1394 dig_in[14] dig_in[20] 14.5168a
Cext_1395 dig_in[14] dig_in[21] 12.1005a
Cext_1396 dig_in[14] dig_in[22] 11.9807a
Cext_1397 dig_in[14] dig_in[23] 14.3547a
Cext_1398 dig_in[14] dig_in[2] 28.9388a
Cext_1399 dig_in[14] dig_in[3] 23.7067a
Cext_1400 dig_in[14] dig_in[4] 38.0614a
Cext_1401 dig_in[14] dig_in[5] 35.6874a
Cext_1402 dig_in[14] dig_in[6] 35.6874a
Cext_1403 dig_in[14] dig_in[7] 35.6874a
Cext_1404 dig_in[14] dig_in[8] 35.6874a
Cext_1405 dig_in[14] dig_in[9] 45.5583a
Cext_1406 dig_in[14] dig_out[0] 30.1534a
Cext_1407 dig_in[14] dig_out[10] 23.7067a
Cext_1408 dig_in[14] dig_out[11] 28.7095a
Cext_1409 dig_in[14] dig_out[1] 23.7067a
Cext_1410 dig_in[14] dig_out[2] 23.7067a
Cext_1411 dig_in[14] dig_out[3] 23.7067a
Cext_1412 dig_in[14] dig_out[4] 23.7067a
Cext_1413 dig_in[14] dig_out[5] 23.7067a
Cext_1414 dig_in[14] dig_out[6] 23.7067a
Cext_1415 dig_in[14] dig_out[7] 23.7067a
Cext_1416 dig_in[14] dig_out[8] 23.7067a
Cext_1417 dig_in[14] dig_out[9] 23.7067a
Cext_1418 dig_in[14] enable 31.2992a
Cext_1419 dig_in[14] rst 64.4055a
Cext_1420 dig_in[14] s0 36.5548a
Cext_1421 dig_in[14] s1 55.9195a
Cext_1422 dig_in[14] s2 948.685a
Cext_1423 dig_in[14] s3 168.111a
Cext_1424 dig_in[14] slow 46.9449a
Cext_1425 dig_in[14] vbias 28.4371a
Cext_1426 dig_in[14] vdd_1v2 25.5516a
Cext_1427 dig_in[14] vdd_3v3 1.92735f
Cext_1428 dig_in[14] vin 262.496a
Cext_1429 dig_in[14] vss_1v2 234.635a
Cext_1430 dig_in[14] vss_3v3 840.173a
Cext_1431 dig_in[15] dig_in[16] 7.52141f
Cext_1432 dig_in[15] dig_in[17] 22.4256a
Cext_1433 dig_in[15] dig_in[18] 21.0164a
Cext_1434 dig_in[15] dig_in[19] 22.7149a
Cext_1435 dig_in[15] dig_in[1] 24.178a
Cext_1436 dig_in[15] dig_in[20] 22.1391a
Cext_1437 dig_in[15] dig_in[21] 19.4805a
Cext_1438 dig_in[15] dig_in[22] 19.4382a
Cext_1439 dig_in[15] dig_in[23] 21.6924a
Cext_1440 dig_in[15] dig_in[2] 29.1692a
Cext_1441 dig_in[15] dig_in[3] 23.7067a
Cext_1442 dig_in[15] dig_in[4] 8.59922f
Cext_1443 dig_in[15] dig_in[5] 54.0259a
Cext_1444 dig_in[15] dig_in[6] 49.6581a
Cext_1445 dig_in[15] dig_in[7] 47.8834a
Cext_1446 dig_in[15] dig_in[8] 487.585a
Cext_1447 dig_in[15] dig_in[9] 55.6219a
Cext_1448 dig_in[15] dig_out[0] 30.1534a
Cext_1449 dig_in[15] dig_out[10] 23.7067a
Cext_1450 dig_in[15] dig_out[11] 28.7095a
Cext_1451 dig_in[15] dig_out[1] 23.7067a
Cext_1452 dig_in[15] dig_out[2] 23.7067a
Cext_1453 dig_in[15] dig_out[3] 23.7067a
Cext_1454 dig_in[15] dig_out[4] 23.7067a
Cext_1455 dig_in[15] dig_out[5] 23.7067a
Cext_1456 dig_in[15] dig_out[6] 23.7067a
Cext_1457 dig_in[15] dig_out[7] 23.7067a
Cext_1458 dig_in[15] dig_out[8] 23.7067a
Cext_1459 dig_in[15] dig_out[9] 23.7067a
Cext_1460 dig_in[15] enable 31.2992a
Cext_1461 dig_in[15] rst 218.248a
Cext_1462 dig_in[15] s0 36.5548a
Cext_1463 dig_in[15] s1 55.9195a
Cext_1464 dig_in[15] s2 89.5703a
Cext_1465 dig_in[15] s3 1.43239f
Cext_1466 dig_in[15] slow 46.3857a
Cext_1467 dig_in[15] vbias 28.4371a
Cext_1468 dig_in[15] vdd_1v2 21.29a
Cext_1469 dig_in[15] vdd_3v3 1.96797f
Cext_1470 dig_in[15] vin 20.1877f
Cext_1471 dig_in[15] vss_1v2 234.755a
Cext_1472 dig_in[15] vss_3v3 974.008a
Cext_1473 dig_in[16] dig_in[17] 33.9907f
Cext_1474 dig_in[16] dig_in[18] 16.205a
Cext_1475 dig_in[16] dig_in[19] 20.1573a
Cext_1476 dig_in[16] dig_in[1] 11.9807a
Cext_1477 dig_in[16] dig_in[20] 0.953108a
Cext_1478 dig_in[16] dig_in[21] 0.561371a
Cext_1479 dig_in[16] dig_in[22] 0.162067a
Cext_1480 dig_in[16] dig_in[23] 0.119784a
Cext_1481 dig_in[16] dig_in[2] 17.4311a
Cext_1482 dig_in[16] dig_in[3] 11.726a
Cext_1483 dig_in[16] dig_in[4] 11.726a
Cext_1484 dig_in[16] dig_in[5] 11.726a
Cext_1485 dig_in[16] dig_in[6] 11.726a
Cext_1486 dig_in[16] dig_in[7] 11.726a
Cext_1487 dig_in[16] dig_in[8] 11.726a
Cext_1488 dig_in[16] dig_in[9] 20.6431a
Cext_1489 dig_in[16] dig_out[0] 18.1727a
Cext_1490 dig_in[16] dig_out[10] 11.726a
Cext_1491 dig_in[16] dig_out[11] 16.7288a
Cext_1492 dig_in[16] dig_out[1] 11.726a
Cext_1493 dig_in[16] dig_out[2] 11.726a
Cext_1494 dig_in[16] dig_out[3] 11.726a
Cext_1495 dig_in[16] dig_out[4] 11.726a
Cext_1496 dig_in[16] dig_out[5] 11.726a
Cext_1497 dig_in[16] dig_out[6] 11.726a
Cext_1498 dig_in[16] dig_out[7] 11.726a
Cext_1499 dig_in[16] dig_out[8] 11.726a
Cext_1500 dig_in[16] dig_out[9] 11.726a
Cext_1501 dig_in[16] enable 19.3185a
Cext_1502 dig_in[16] gs 18.7525a
Cext_1503 dig_in[16] gw 532.898a
Cext_1504 dig_in[16] vbias 16.4564a
Cext_1505 dig_in[16] vdd_1v2 177.597a
Cext_1506 dig_in[16] vdd_3v3 285.848a
Cext_1507 dig_in[16] vss_1v2 129.028a
Cext_1508 dig_in[16] vss_3v3 3.12868f
Cext_1509 dig_in[17] dig_in[18] 18.4009f
Cext_1510 dig_in[17] dig_in[19] 21.9968a
Cext_1511 dig_in[17] dig_in[1] 11.9807a
Cext_1512 dig_in[17] dig_in[20] 1.494a
Cext_1513 dig_in[17] dig_in[21] 0.953108a
Cext_1514 dig_in[17] dig_in[22] 0.561371a
Cext_1515 dig_in[17] dig_in[23] 0.162067a
Cext_1516 dig_in[17] dig_in[2] 17.904a
Cext_1517 dig_in[17] dig_in[3] 11.726a
Cext_1518 dig_in[17] dig_in[4] 11.726a
Cext_1519 dig_in[17] dig_in[5] 11.726a
Cext_1520 dig_in[17] dig_in[6] 11.726a
Cext_1521 dig_in[17] dig_in[7] 11.726a
Cext_1522 dig_in[17] dig_in[8] 11.726a
Cext_1523 dig_in[17] dig_in[9] 20.3681a
Cext_1524 dig_in[17] dig_out[0] 18.1727a
Cext_1525 dig_in[17] dig_out[10] 11.726a
Cext_1526 dig_in[17] dig_out[11] 16.7288a
Cext_1527 dig_in[17] dig_out[1] 11.726a
Cext_1528 dig_in[17] dig_out[2] 11.726a
Cext_1529 dig_in[17] dig_out[3] 11.726a
Cext_1530 dig_in[17] dig_out[4] 11.726a
Cext_1531 dig_in[17] dig_out[5] 11.726a
Cext_1532 dig_in[17] dig_out[6] 11.726a
Cext_1533 dig_in[17] dig_out[7] 11.726a
Cext_1534 dig_in[17] dig_out[8] 11.726a
Cext_1535 dig_in[17] dig_out[9] 11.726a
Cext_1536 dig_in[17] enable 19.3185a
Cext_1537 dig_in[17] gs 1.88864f
Cext_1538 dig_in[17] gw 5.46198f
Cext_1539 dig_in[17] vbias 16.4564a
Cext_1540 dig_in[17] vdd_1v2 168.101a
Cext_1541 dig_in[17] vdd_3v3 588.1a
Cext_1542 dig_in[17] vss_1v2 128.825a
Cext_1543 dig_in[17] vss_3v3 1.97245f
Cext_1544 dig_in[18] dig_in[19] 31.2123f
Cext_1545 dig_in[18] dig_in[1] 11.9807a
Cext_1546 dig_in[18] dig_in[20] 2.55377a
Cext_1547 dig_in[18] dig_in[21] 1.494a
Cext_1548 dig_in[18] dig_in[22] 0.953108a
Cext_1549 dig_in[18] dig_in[23] 0.561371a
Cext_1550 dig_in[18] dig_in[2] 18.916a
Cext_1551 dig_in[18] dig_in[3] 11.726a
Cext_1552 dig_in[18] dig_in[4] 11.726a
Cext_1553 dig_in[18] dig_in[5] 11.726a
Cext_1554 dig_in[18] dig_in[6] 11.726a
Cext_1555 dig_in[18] dig_in[7] 11.726a
Cext_1556 dig_in[18] dig_in[8] 11.726a
Cext_1557 dig_in[18] dig_in[9] 20.1609a
Cext_1558 dig_in[18] dig_out[0] 18.1727a
Cext_1559 dig_in[18] dig_out[10] 11.726a
Cext_1560 dig_in[18] dig_out[11] 16.7288a
Cext_1561 dig_in[18] dig_out[1] 11.726a
Cext_1562 dig_in[18] dig_out[2] 11.726a
Cext_1563 dig_in[18] dig_out[3] 11.726a
Cext_1564 dig_in[18] dig_out[4] 11.726a
Cext_1565 dig_in[18] dig_out[5] 11.726a
Cext_1566 dig_in[18] dig_out[6] 11.726a
Cext_1567 dig_in[18] dig_out[7] 11.726a
Cext_1568 dig_in[18] dig_out[8] 11.726a
Cext_1569 dig_in[18] dig_out[9] 11.726a
Cext_1570 dig_in[18] enable 19.4375a
Cext_1571 dig_in[18] gs 18.7525a
Cext_1572 dig_in[18] gw 569.972a
Cext_1573 dig_in[18] vbias 16.4564a
Cext_1574 dig_in[18] vdd_1v2 159.303a
Cext_1575 dig_in[18] vdd_3v3 1.85487f
Cext_1576 dig_in[18] vss_1v2 128.855a
Cext_1577 dig_in[18] vss_3v3 1.82663f
Cext_1578 dig_in[19] dig_in[1] 11.9807a
Cext_1579 dig_in[19] dig_in[20] 5.32805f
Cext_1580 dig_in[19] dig_in[21] 2.55377a
Cext_1581 dig_in[19] dig_in[22] 1.494a
Cext_1582 dig_in[19] dig_in[23] 0.953108a
Cext_1583 dig_in[19] dig_in[2] 5.23866f
Cext_1584 dig_in[19] dig_in[3] 15.1879a
Cext_1585 dig_in[19] dig_in[4] 14.9585a
Cext_1586 dig_in[19] dig_in[5] 14.9585a
Cext_1587 dig_in[19] dig_in[6] 14.9585a
Cext_1588 dig_in[19] dig_in[7] 14.9585a
Cext_1589 dig_in[19] dig_in[8] 14.9585a
Cext_1590 dig_in[19] dig_in[9] 23.2316a
Cext_1591 dig_in[19] dig_out[0] 18.1727a
Cext_1592 dig_in[19] dig_out[10] 11.726a
Cext_1593 dig_in[19] dig_out[11] 16.7288a
Cext_1594 dig_in[19] dig_out[1] 11.726a
Cext_1595 dig_in[19] dig_out[2] 11.726a
Cext_1596 dig_in[19] dig_out[3] 11.726a
Cext_1597 dig_in[19] dig_out[4] 11.726a
Cext_1598 dig_in[19] dig_out[5] 11.726a
Cext_1599 dig_in[19] dig_out[6] 11.726a
Cext_1600 dig_in[19] dig_out[7] 11.726a
Cext_1601 dig_in[19] dig_out[8] 11.726a
Cext_1602 dig_in[19] dig_out[9] 11.726a
Cext_1603 dig_in[19] enable 19.4793a
Cext_1604 dig_in[19] gs 1.88864f
Cext_1605 dig_in[19] gw 5.47279f
Cext_1606 dig_in[19] vbias 18.8304a
Cext_1607 dig_in[19] vdd_1v2 171.684a
Cext_1608 dig_in[19] vdd_3v3 1.92456f
Cext_1609 dig_in[19] vss_1v2 128.855a
Cext_1610 dig_in[19] vss_3v3 199.251a
Cext_1611 dig_in[1] dig_in[20] 11.9807a
Cext_1612 dig_in[1] dig_in[21] 11.9807a
Cext_1613 dig_in[1] dig_in[22] 11.9807a
Cext_1614 dig_in[1] dig_in[23] 11.9807a
Cext_1615 dig_in[1] dig_in[2] 21.657f
Cext_1616 dig_in[1] dig_in[3] 44.6949a
Cext_1617 dig_in[1] dig_in[4] 24.4789a
Cext_1618 dig_in[1] dig_in[5] 24.3094a
Cext_1619 dig_in[1] dig_in[6] 24.1915a
Cext_1620 dig_in[1] dig_in[7] 24.0716a
Cext_1621 dig_in[1] dig_in[8] 24.0812a
Cext_1622 dig_in[1] dig_in[9] 23.9614a
Cext_1623 dig_in[1] dig_out[0] 30.1534a
Cext_1624 dig_in[1] dig_out[10] 23.7067a
Cext_1625 dig_in[1] dig_out[11] 34.5197a
Cext_1626 dig_in[1] dig_out[1] 23.7067a
Cext_1627 dig_in[1] dig_out[2] 23.7067a
Cext_1628 dig_in[1] dig_out[3] 23.7067a
Cext_1629 dig_in[1] dig_out[4] 23.7067a
Cext_1630 dig_in[1] dig_out[5] 23.7067a
Cext_1631 dig_in[1] dig_out[6] 23.7067a
Cext_1632 dig_in[1] dig_out[7] 23.7067a
Cext_1633 dig_in[1] dig_out[8] 23.7067a
Cext_1634 dig_in[1] dig_out[9] 23.7067a
Cext_1635 dig_in[1] enable 31.2992a
Cext_1636 dig_in[1] rst 44.5156a
Cext_1637 dig_in[1] s0 36.5548a
Cext_1638 dig_in[1] s1 745.127a
Cext_1639 dig_in[1] s2 85.6153a
Cext_1640 dig_in[1] s3 168.111a
Cext_1641 dig_in[1] slow 47.3441a
Cext_1642 dig_in[1] vbias 18.1107a
Cext_1643 dig_in[1] vdd_1v2 62.1567a
Cext_1644 dig_in[1] vdd_3v3 685.519a
Cext_1645 dig_in[1] vin 180.158a
Cext_1646 dig_in[1] vss_1v2 237.235a
Cext_1647 dig_in[1] vss_3v3 6.76798f
Cext_1648 dig_in[20] dig_in[21] 38.919f
Cext_1649 dig_in[20] dig_in[22] 4.71153a
Cext_1650 dig_in[20] dig_in[23] 2.11646a
Cext_1651 dig_in[20] dig_in[2] 5.15912f
Cext_1652 dig_in[20] dig_in[3] 20.9948a
Cext_1653 dig_in[20] dig_in[4] 15.4182a
Cext_1654 dig_in[20] dig_in[5] 15.1879a
Cext_1655 dig_in[20] dig_in[6] 14.9585a
Cext_1656 dig_in[20] dig_in[7] 14.9585a
Cext_1657 dig_in[20] dig_in[8] 14.9585a
Cext_1658 dig_in[20] dig_in[9] 25.1606a
Cext_1659 dig_in[20] dig_out[0] 18.1727a
Cext_1660 dig_in[20] dig_out[10] 11.726a
Cext_1661 dig_in[20] dig_out[11] 17.0599a
Cext_1662 dig_in[20] dig_out[1] 11.726a
Cext_1663 dig_in[20] dig_out[2] 11.726a
Cext_1664 dig_in[20] dig_out[3] 11.726a
Cext_1665 dig_in[20] dig_out[4] 11.726a
Cext_1666 dig_in[20] dig_out[5] 11.726a
Cext_1667 dig_in[20] dig_out[6] 11.726a
Cext_1668 dig_in[20] dig_out[7] 11.726a
Cext_1669 dig_in[20] dig_out[8] 11.726a
Cext_1670 dig_in[20] dig_out[9] 11.726a
Cext_1671 dig_in[20] enable 19.5466a
Cext_1672 dig_in[20] gs 34.485a
Cext_1673 dig_in[20] gw 537.133a
Cext_1674 dig_in[20] vbias 75.7499a
Cext_1675 dig_in[20] vdd_1v2 105.737a
Cext_1676 dig_in[20] vdd_3v3 129.566a
Cext_1677 dig_in[20] vss_1v2 128.855a
Cext_1678 dig_in[20] vss_3v3 3.32062f
Cext_1679 dig_in[21] dig_in[22] 34.4445f
Cext_1680 dig_in[21] dig_in[23] 4.71153a
Cext_1681 dig_in[21] dig_in[2] 17.0198a
Cext_1682 dig_in[21] dig_in[3] 18.2351a
Cext_1683 dig_in[21] dig_in[4] 12.4284a
Cext_1684 dig_in[21] dig_in[5] 12.1857a
Cext_1685 dig_in[21] dig_in[6] 11.9554a
Cext_1686 dig_in[21] dig_in[7] 11.726a
Cext_1687 dig_in[21] dig_in[8] 11.726a
Cext_1688 dig_in[21] dig_in[9] 19.7626a
Cext_1689 dig_in[21] dig_out[0] 18.1727a
Cext_1690 dig_in[21] dig_out[10] 11.726a
Cext_1691 dig_in[21] dig_out[11] 17.0599a
Cext_1692 dig_in[21] dig_out[1] 11.726a
Cext_1693 dig_in[21] dig_out[2] 11.726a
Cext_1694 dig_in[21] dig_out[3] 11.726a
Cext_1695 dig_in[21] dig_out[4] 11.726a
Cext_1696 dig_in[21] dig_out[5] 11.726a
Cext_1697 dig_in[21] dig_out[6] 11.726a
Cext_1698 dig_in[21] dig_out[7] 11.726a
Cext_1699 dig_in[21] dig_out[8] 11.726a
Cext_1700 dig_in[21] dig_out[9] 11.726a
Cext_1701 dig_in[21] enable 19.6629a
Cext_1702 dig_in[21] gs 844.148a
Cext_1703 dig_in[21] gw 990.839a
Cext_1704 dig_in[21] vbias 3.14418f
Cext_1705 dig_in[21] vdd_1v2 105.737a
Cext_1706 dig_in[21] vdd_3v3 95.6194a
Cext_1707 dig_in[21] vss_1v2 128.855a
Cext_1708 dig_in[21] vss_3v3 221.123a
Cext_1709 dig_in[22] dig_in[23] 40.8317f
Cext_1710 dig_in[22] dig_in[2] 16.0479a
Cext_1711 dig_in[22] dig_in[3] 19.2472a
Cext_1712 dig_in[22] dig_in[4] 12.9012a
Cext_1713 dig_in[22] dig_in[5] 12.4284a
Cext_1714 dig_in[22] dig_in[6] 12.1857a
Cext_1715 dig_in[22] dig_in[7] 11.9554a
Cext_1716 dig_in[22] dig_in[8] 11.726a
Cext_1717 dig_in[22] dig_in[9] 19.6735a
Cext_1718 dig_in[22] dig_out[0] 18.1727a
Cext_1719 dig_in[22] dig_out[10] 11.726a
Cext_1720 dig_in[22] dig_out[11] 17.0599a
Cext_1721 dig_in[22] dig_out[1] 11.726a
Cext_1722 dig_in[22] dig_out[2] 11.726a
Cext_1723 dig_in[22] dig_out[3] 11.726a
Cext_1724 dig_in[22] dig_out[4] 11.726a
Cext_1725 dig_in[22] dig_out[5] 11.726a
Cext_1726 dig_in[22] dig_out[6] 11.726a
Cext_1727 dig_in[22] dig_out[7] 11.726a
Cext_1728 dig_in[22] dig_out[8] 11.726a
Cext_1729 dig_in[22] dig_out[9] 11.726a
Cext_1730 dig_in[22] enable 19.8809a
Cext_1731 dig_in[22] gs 34.596a
Cext_1732 dig_in[22] gw 548.278a
Cext_1733 dig_in[22] vbias 37.2907a
Cext_1734 dig_in[22] vdd_1v2 105.737a
Cext_1735 dig_in[22] vdd_3v3 95.6194a
Cext_1736 dig_in[22] vss_1v2 128.855a
Cext_1737 dig_in[22] vss_3v3 487.072a
Cext_1738 dig_in[23] dig_in[2] 15.5938a
Cext_1739 dig_in[23] dig_in[3] 4.92343f
Cext_1740 dig_in[23] dig_in[4] 205.525a
Cext_1741 dig_in[23] dig_in[5] 33.6859a
Cext_1742 dig_in[23] dig_in[6] 29.7013a
Cext_1743 dig_in[23] dig_in[7] 27.5409a
Cext_1744 dig_in[23] dig_in[8] 26.1009a
Cext_1745 dig_in[23] dig_in[9] 32.91a
Cext_1746 dig_in[23] dig_out[0] 18.1727a
Cext_1747 dig_in[23] dig_out[10] 11.726a
Cext_1748 dig_in[23] dig_out[11] 17.0599a
Cext_1749 dig_in[23] dig_out[1] 11.726a
Cext_1750 dig_in[23] dig_out[2] 11.726a
Cext_1751 dig_in[23] dig_out[3] 11.726a
Cext_1752 dig_in[23] dig_out[4] 11.726a
Cext_1753 dig_in[23] dig_out[5] 11.726a
Cext_1754 dig_in[23] dig_out[6] 11.726a
Cext_1755 dig_in[23] dig_out[7] 11.726a
Cext_1756 dig_in[23] dig_out[8] 11.726a
Cext_1757 dig_in[23] dig_out[9] 11.726a
Cext_1758 dig_in[23] enable 2.34569f
Cext_1759 dig_in[23] gs 844.301a
Cext_1760 dig_in[23] gw 996.843a
Cext_1761 dig_in[23] reset 215.309a
Cext_1762 dig_in[23] vbias 39.1328a
Cext_1763 dig_in[23] vdd_1v2 105.737a
Cext_1764 dig_in[23] vdd_3v3 130.292a
Cext_1765 dig_in[23] vss_1v2 128.855a
Cext_1766 dig_in[23] vss_3v3 283.931a
Cext_1767 dig_in[2] dig_in[3] 27.4348f
Cext_1768 dig_in[2] dig_in[4] 25.1327a
Cext_1769 dig_in[2] dig_in[5] 24.5308a
Cext_1770 dig_in[2] dig_in[6] 24.3094a
Cext_1771 dig_in[2] dig_in[7] 24.1396a
Cext_1772 dig_in[2] dig_in[8] 24.1235a
Cext_1773 dig_in[2] dig_in[9] 24.0812a
Cext_1774 dig_in[2] dig_out[0] 30.1534a
Cext_1775 dig_in[2] dig_out[10] 23.7067a
Cext_1776 dig_in[2] dig_out[11] 82.2584a
Cext_1777 dig_in[2] dig_out[1] 23.7067a
Cext_1778 dig_in[2] dig_out[2] 23.7067a
Cext_1779 dig_in[2] dig_out[3] 23.7067a
Cext_1780 dig_in[2] dig_out[4] 23.7067a
Cext_1781 dig_in[2] dig_out[5] 23.7067a
Cext_1782 dig_in[2] dig_out[6] 23.7067a
Cext_1783 dig_in[2] dig_out[7] 23.7067a
Cext_1784 dig_in[2] dig_out[8] 23.7067a
Cext_1785 dig_in[2] dig_out[9] 23.7067a
Cext_1786 dig_in[2] enable 31.2992a
Cext_1787 dig_in[2] rst 44.7665a
Cext_1788 dig_in[2] s0 36.5548a
Cext_1789 dig_in[2] s1 55.9195a
Cext_1790 dig_in[2] s2 948.685a
Cext_1791 dig_in[2] s3 168.111a
Cext_1792 dig_in[2] slow 46.8154a
Cext_1793 dig_in[2] vbias 95.7311a
Cext_1794 dig_in[2] vdd_3v3 652a
Cext_1795 dig_in[2] vin 183.422a
Cext_1796 dig_in[2] vss_1v2 233.76a
Cext_1797 dig_in[2] vss_3v3 6.49785f
Cext_1798 dig_in[3] dig_in[4] 6.37726f
Cext_1799 dig_in[3] dig_in[5] 27.0686a
Cext_1800 dig_in[3] dig_in[6] 25.6593a
Cext_1801 dig_in[3] dig_in[7] 24.932a
Cext_1802 dig_in[3] dig_in[8] 24.633a
Cext_1803 dig_in[3] dig_in[9] 24.34a
Cext_1804 dig_in[3] dig_out[0] 30.1534a
Cext_1805 dig_in[3] dig_out[10] 23.7067a
Cext_1806 dig_in[3] dig_out[11] 48.8717a
Cext_1807 dig_in[3] dig_out[1] 23.7067a
Cext_1808 dig_in[3] dig_out[2] 23.7067a
Cext_1809 dig_in[3] dig_out[3] 23.7067a
Cext_1810 dig_in[3] dig_out[4] 23.7067a
Cext_1811 dig_in[3] dig_out[5] 23.7067a
Cext_1812 dig_in[3] dig_out[6] 23.7067a
Cext_1813 dig_in[3] dig_out[7] 23.7067a
Cext_1814 dig_in[3] dig_out[8] 23.7067a
Cext_1815 dig_in[3] dig_out[9] 23.7067a
Cext_1816 dig_in[3] enable 31.2992a
Cext_1817 dig_in[3] rst 44.7232a
Cext_1818 dig_in[3] s0 36.5548a
Cext_1819 dig_in[3] s1 55.9195a
Cext_1820 dig_in[3] s2 89.5703a
Cext_1821 dig_in[3] s3 1.43239f
Cext_1822 dig_in[3] slow 46.1729a
Cext_1823 dig_in[3] vbias 857.644a
Cext_1824 dig_in[3] vdd_3v3 705.232a
Cext_1825 dig_in[3] vin 20.0731f
Cext_1826 dig_in[3] vss_1v2 233.76a
Cext_1827 dig_in[3] vss_3v3 1.40019f
Cext_1828 dig_in[4] dig_in[5] 36.3982f
Cext_1829 dig_in[4] dig_in[6] 42.4171a
Cext_1830 dig_in[4] dig_in[7] 40.327a
Cext_1831 dig_in[4] dig_in[8] 24.9839a
Cext_1832 dig_in[4] dig_in[9] 27.5716a
Cext_1833 dig_in[4] dig_out[0] 30.1534a
Cext_1834 dig_in[4] dig_out[10] 23.7067a
Cext_1835 dig_in[4] dig_out[11] 32.6238a
Cext_1836 dig_in[4] dig_out[1] 23.7067a
Cext_1837 dig_in[4] dig_out[2] 23.7067a
Cext_1838 dig_in[4] dig_out[3] 23.7067a
Cext_1839 dig_in[4] dig_out[4] 23.7067a
Cext_1840 dig_in[4] dig_out[5] 23.7067a
Cext_1841 dig_in[4] dig_out[6] 23.7067a
Cext_1842 dig_in[4] dig_out[7] 23.7067a
Cext_1843 dig_in[4] dig_out[8] 23.7067a
Cext_1844 dig_in[4] dig_out[9] 23.7067a
Cext_1845 dig_in[4] enable 31.5157a
Cext_1846 dig_in[4] rst 102.098a
Cext_1847 dig_in[4] s0 643.75a
Cext_1848 dig_in[4] s1 51.3775a
Cext_1849 dig_in[4] s2 84.7481a
Cext_1850 dig_in[4] s3 168.111a
Cext_1851 dig_in[4] slow 47.8616a
Cext_1852 dig_in[4] vbias 26.3354a
Cext_1853 dig_in[4] vdd_3v3 2.95243f
Cext_1854 dig_in[4] vin 237.85a
Cext_1855 dig_in[4] vss_1v2 233.76a
Cext_1856 dig_in[4] vss_3v3 695.148a
Cext_1857 dig_in[5] dig_in[6] 36.4455f
Cext_1858 dig_in[5] dig_in[7] 42.3652a
Cext_1859 dig_in[5] dig_in[8] 25.6593a
Cext_1860 dig_in[5] dig_in[9] 27.9225a
Cext_1861 dig_in[5] dig_out[0] 30.2681a
Cext_1862 dig_in[5] dig_out[10] 23.7067a
Cext_1863 dig_in[5] dig_out[11] 32.3488a
Cext_1864 dig_in[5] dig_out[1] 23.7067a
Cext_1865 dig_in[5] dig_out[2] 23.7067a
Cext_1866 dig_in[5] dig_out[3] 23.7067a
Cext_1867 dig_in[5] dig_out[4] 23.7067a
Cext_1868 dig_in[5] dig_out[5] 23.7067a
Cext_1869 dig_in[5] dig_out[6] 23.7067a
Cext_1870 dig_in[5] dig_out[7] 23.7067a
Cext_1871 dig_in[5] dig_out[8] 23.7067a
Cext_1872 dig_in[5] dig_out[9] 23.7067a
Cext_1873 dig_in[5] enable 31.7406a
Cext_1874 dig_in[5] rst 69.1152a
Cext_1875 dig_in[5] s0 36.5548a
Cext_1876 dig_in[5] s1 745.127a
Cext_1877 dig_in[5] s2 85.6153a
Cext_1878 dig_in[5] s3 168.111a
Cext_1879 dig_in[5] slow 47.2759a
Cext_1880 dig_in[5] vbias 23.9614a
Cext_1881 dig_in[5] vdd_3v3 2.58559f
Cext_1882 dig_in[5] vin 200.884a
Cext_1883 dig_in[5] vss_1v2 233.76a
Cext_1884 dig_in[5] vss_3v3 718.489a
Cext_1885 dig_in[6] dig_in[7] 36.4944f
Cext_1886 dig_in[6] dig_in[8] 27.0686a
Cext_1887 dig_in[6] dig_in[9] 28.5979a
Cext_1888 dig_in[6] dig_out[0] 30.4494a
Cext_1889 dig_in[6] dig_out[10] 23.7067a
Cext_1890 dig_in[6] dig_out[11] 32.1416a
Cext_1891 dig_in[6] dig_out[1] 23.8214a
Cext_1892 dig_in[6] dig_out[2] 23.7067a
Cext_1893 dig_in[6] dig_out[3] 23.7067a
Cext_1894 dig_in[6] dig_out[4] 23.7067a
Cext_1895 dig_in[6] dig_out[5] 23.7067a
Cext_1896 dig_in[6] dig_out[6] 23.7067a
Cext_1897 dig_in[6] dig_out[7] 23.7067a
Cext_1898 dig_in[6] dig_out[8] 23.7067a
Cext_1899 dig_in[6] dig_out[9] 23.7067a
Cext_1900 dig_in[6] enable 31.9737a
Cext_1901 dig_in[6] rst 68.6299a
Cext_1902 dig_in[6] s0 36.5548a
Cext_1903 dig_in[6] s1 55.9195a
Cext_1904 dig_in[6] s2 948.685a
Cext_1905 dig_in[6] s3 168.111a
Cext_1906 dig_in[6] slow 46.7555a
Cext_1907 dig_in[6] vbias 23.9614a
Cext_1908 dig_in[6] vdd_3v3 1.6512f
Cext_1909 dig_in[6] vin 203.054a
Cext_1910 dig_in[6] vss_1v2 233.76a
Cext_1911 dig_in[6] vss_3v3 767.661a
Cext_1912 dig_in[7] dig_in[8] 15.5737f
Cext_1913 dig_in[7] dig_in[9] 30.0072a
Cext_1914 dig_in[7] dig_out[0] 30.6056a
Cext_1915 dig_in[7] dig_out[10] 23.8214a
Cext_1916 dig_in[7] dig_out[11] 31.9798a
Cext_1917 dig_in[7] dig_out[1] 24.0027a
Cext_1918 dig_in[7] dig_out[2] 23.7067a
Cext_1919 dig_in[7] dig_out[3] 23.7067a
Cext_1920 dig_in[7] dig_out[4] 23.7067a
Cext_1921 dig_in[7] dig_out[5] 23.7067a
Cext_1922 dig_in[7] dig_out[6] 23.7067a
Cext_1923 dig_in[7] dig_out[7] 23.7067a
Cext_1924 dig_in[7] dig_out[8] 23.7067a
Cext_1925 dig_in[7] dig_out[9] 23.7067a
Cext_1926 dig_in[7] enable 32.4277a
Cext_1927 dig_in[7] rst 68.2095a
Cext_1928 dig_in[7] s0 36.5548a
Cext_1929 dig_in[7] s1 55.9195a
Cext_1930 dig_in[7] s2 89.5703a
Cext_1931 dig_in[7] s3 1.43239f
Cext_1932 dig_in[7] slow 46.2186a
Cext_1933 dig_in[7] vbias 23.9614a
Cext_1934 dig_in[7] vdd_3v3 1.46404f
Cext_1935 dig_in[7] vin 20.0932f
Cext_1936 dig_in[7] vss_1v2 233.76a
Cext_1937 dig_in[7] vss_3v3 887.196a
Cext_1938 dig_in[8] dig_in[9] 39.9382f
Cext_1939 dig_in[8] dig_out[0] 30.91a
Cext_1940 dig_in[8] dig_out[10] 24.0027a
Cext_1941 dig_in[8] dig_out[11] 31.9646a
Cext_1942 dig_in[8] dig_out[1] 24.159a
Cext_1943 dig_in[8] dig_out[2] 23.7067a
Cext_1944 dig_in[8] dig_out[3] 23.7067a
Cext_1945 dig_in[8] dig_out[4] 23.7067a
Cext_1946 dig_in[8] dig_out[5] 23.7067a
Cext_1947 dig_in[8] dig_out[6] 23.7067a
Cext_1948 dig_in[8] dig_out[7] 23.7067a
Cext_1949 dig_in[8] dig_out[8] 23.7067a
Cext_1950 dig_in[8] dig_out[9] 23.7067a
Cext_1951 dig_in[8] enable 33.3997a
Cext_1952 dig_in[8] rst 99.6461a
Cext_1953 dig_in[8] s0 643.75a
Cext_1954 dig_in[8] s1 51.3775a
Cext_1955 dig_in[8] s2 84.7481a
Cext_1956 dig_in[8] s3 168.111a
Cext_1957 dig_in[8] slow 48.0063a
Cext_1958 dig_in[8] vbias 23.9614a
Cext_1959 dig_in[8] vdd_3v3 3.18188f
Cext_1960 dig_in[8] vin 274.164a
Cext_1961 dig_in[8] vss_1v2 233.76a
Cext_1962 dig_in[8] vss_3v3 749.596a
Cext_1963 dig_in[9] dig_out[0] 38.8994a
Cext_1964 dig_in[9] dig_out[10] 31.4967a
Cext_1965 dig_in[9] dig_out[11] 39.377a
Cext_1966 dig_in[9] dig_out[1] 31.8011a
Cext_1967 dig_in[9] dig_out[2] 31.1592a
Cext_1968 dig_in[9] dig_out[3] 31.0445a
Cext_1969 dig_in[9] dig_out[4] 31.0445a
Cext_1970 dig_in[9] dig_out[5] 31.0445a
Cext_1971 dig_in[9] dig_out[6] 31.0445a
Cext_1972 dig_in[9] dig_out[7] 31.0445a
Cext_1973 dig_in[9] dig_out[8] 31.0445a
Cext_1974 dig_in[9] dig_out[9] 31.0445a
Cext_1975 dig_in[9] enable 5.32789f
Cext_1976 dig_in[9] rst 88.0891a
Cext_1977 dig_in[9] s0 36.5548a
Cext_1978 dig_in[9] s1 745.127a
Cext_1979 dig_in[9] s2 85.6153a
Cext_1980 dig_in[9] s3 168.111a
Cext_1981 dig_in[9] slow 47.4918a
Cext_1982 dig_in[9] vbias 31.2992a
Cext_1983 dig_in[9] vdd_3v3 2.81163f
Cext_1984 dig_in[9] vin 226.319a
Cext_1985 dig_in[9] vss_1v2 233.76a
Cext_1986 dig_in[9] vss_3v3 739.217a
Cext_1987 dig_out[0] dig_out[10] 30.3117a
Cext_1988 dig_out[0] dig_out[11] 34.6304a
Cext_1989 dig_out[0] dig_out[1] 41.8269f
Cext_1990 dig_out[0] dig_out[2] 29.9749a
Cext_1991 dig_out[0] dig_out[3] 28.5182a
Cext_1992 dig_out[0] dig_out[4] 27.5858a
Cext_1993 dig_out[0] dig_out[5] 27.033a
Cext_1994 dig_out[0] dig_out[6] 26.965a
Cext_1995 dig_out[0] dig_out[7] 26.9227a
Cext_1996 dig_out[0] dig_out[8] 26.8029a
Cext_1997 dig_out[0] dig_out[9] 26.8029a
Cext_1998 dig_out[0] enable 35.5381f
Cext_1999 dig_out[0] vbias 28.4371a
Cext_2000 dig_out[0] vdd_1v2 2.59405f
Cext_2001 dig_out[0] vdd_3v3 95.6194a
Cext_2002 dig_out[0] vss_1v2 6.21209f
Cext_2003 dig_out[0] vss_3v3 309.645a
Cext_2004 dig_out[10] dig_out[11] 43.9122f
Cext_2005 dig_out[10] dig_out[1] 39.5434f
Cext_2006 dig_out[10] dig_out[2] 75.9497a
Cext_2007 dig_out[10] dig_out[3] 49.8613a
Cext_2008 dig_out[10] dig_out[4] 49.2524a
Cext_2009 dig_out[10] dig_out[5] 49.0619a
Cext_2010 dig_out[10] dig_out[6] 48.895a
Cext_2011 dig_out[10] dig_out[7] 48.9842a
Cext_2012 dig_out[10] dig_out[8] 49.7073a
Cext_2013 dig_out[10] dig_out[9] 4.12971f
Cext_2014 dig_out[10] enable 93.4435a
Cext_2015 dig_out[10] vbias 28.4371a
Cext_2016 dig_out[10] vdd_1v2 521.987a
Cext_2017 dig_out[10] vdd_3v3 95.6194a
Cext_2018 dig_out[10] vss_1v2 314.166a
Cext_2019 dig_out[10] vss_3v3 297.657a
Cext_2020 dig_out[11] dig_out[1] 41.0319a
Cext_2021 dig_out[11] dig_out[2] 39.5604f
Cext_2022 dig_out[11] dig_out[3] 68.4581a
Cext_2023 dig_out[11] dig_out[4] 63.6493a
Cext_2024 dig_out[11] dig_out[5] 61.6671a
Cext_2025 dig_out[11] dig_out[6] 60.7489a
Cext_2026 dig_out[11] dig_out[7] 60.2493a
Cext_2027 dig_out[11] dig_out[8] 60.0056a
Cext_2028 dig_out[11] dig_out[9] 85.4378a
Cext_2029 dig_out[11] enable 31.0307a
Cext_2030 dig_out[11] vbias 33.5001a
Cext_2031 dig_out[11] vdd_1v2 512.18a
Cext_2032 dig_out[11] vdd_3v3 95.6194a
Cext_2033 dig_out[11] vss_1v2 256.724a
Cext_2034 dig_out[11] vss_3v3 304.432a
Cext_2035 dig_out[1] dig_out[2] 4.09152f
Cext_2036 dig_out[1] dig_out[3] 39.6671a
Cext_2037 dig_out[1] dig_out[4] 38.1382a
Cext_2038 dig_out[1] dig_out[5] 37.0624a
Cext_2039 dig_out[1] dig_out[6] 36.5682a
Cext_2040 dig_out[1] dig_out[7] 36.4511a
Cext_2041 dig_out[1] dig_out[8] 36.2941a
Cext_2042 dig_out[1] dig_out[9] 36.1744a
Cext_2043 dig_out[1] enable 31.4766a
Cext_2044 dig_out[1] vbias 28.4371a
Cext_2045 dig_out[1] vdd_1v2 2.50042f
Cext_2046 dig_out[1] vdd_3v3 95.6194a
Cext_2047 dig_out[1] vss_1v2 340.286a
Cext_2048 dig_out[1] vss_3v3 299.976a
Cext_2049 dig_out[2] dig_out[3] 44.0132f
Cext_2050 dig_out[2] dig_out[4] 42.0491a
Cext_2051 dig_out[2] dig_out[5] 39.4655a
Cext_2052 dig_out[2] dig_out[6] 38.0389a
Cext_2053 dig_out[2] dig_out[7] 37.3056a
Cext_2054 dig_out[2] dig_out[8] 36.6677a
Cext_2055 dig_out[2] dig_out[9] 36.2941a
Cext_2056 dig_out[2] enable 17.2727a
Cext_2057 dig_out[2] vbias 28.4371a
Cext_2058 dig_out[2] vdd_1v2 529.678a
Cext_2059 dig_out[2] vdd_3v3 95.6194a
Cext_2060 dig_out[2] vss_1v2 334.529a
Cext_2061 dig_out[2] vss_3v3 298.575a
Cext_2062 dig_out[3] dig_out[4] 44.0632f
Cext_2063 dig_out[3] dig_out[5] 37.4761a
Cext_2064 dig_out[3] dig_out[6] 34.8836a
Cext_2065 dig_out[3] dig_out[7] 33.6099a
Cext_2066 dig_out[3] dig_out[8] 32.7882a
Cext_2067 dig_out[3] dig_out[9] 32.192a
Cext_2068 dig_out[3] enable 16.9933a
Cext_2069 dig_out[3] vbias 28.4371a
Cext_2070 dig_out[3] vdd_1v2 526.017a
Cext_2071 dig_out[3] vdd_3v3 95.6194a
Cext_2072 dig_out[3] vss_1v2 325.201a
Cext_2073 dig_out[3] vss_3v3 298.607a
Cext_2074 dig_out[4] dig_out[5] 44.1177f
Cext_2075 dig_out[4] dig_out[6] 37.5735a
Cext_2076 dig_out[4] dig_out[7] 34.8836a
Cext_2077 dig_out[4] dig_out[8] 33.5661a
Cext_2078 dig_out[4] dig_out[9] 32.7882a
Cext_2079 dig_out[4] enable 16.6493a
Cext_2080 dig_out[4] vbias 28.6537a
Cext_2081 dig_out[4] vdd_1v2 524.525a
Cext_2082 dig_out[4] vdd_3v3 95.6194a
Cext_2083 dig_out[4] vss_1v2 321.164a
Cext_2084 dig_out[4] vss_3v3 297.657a
Cext_2085 dig_out[5] dig_out[6] 44.1722f
Cext_2086 dig_out[5] dig_out[7] 37.5216a
Cext_2087 dig_out[5] dig_out[8] 34.7585a
Cext_2088 dig_out[5] dig_out[9] 33.5392a
Cext_2089 dig_out[5] enable 16.6493a
Cext_2090 dig_out[5] vbias 28.8785a
Cext_2091 dig_out[5] vdd_1v2 523.415a
Cext_2092 dig_out[5] vdd_3v3 95.6194a
Cext_2093 dig_out[5] vss_1v2 319.003a
Cext_2094 dig_out[5] vss_3v3 297.613a
Cext_2095 dig_out[6] dig_out[7] 44.2268f
Cext_2096 dig_out[6] dig_out[8] 37.4371a
Cext_2097 dig_out[6] dig_out[9] 34.8522a
Cext_2098 dig_out[6] enable 16.6493a
Cext_2099 dig_out[6] vbias 29.1116a
Cext_2100 dig_out[6] vdd_1v2 522.049a
Cext_2101 dig_out[6] vdd_3v3 95.6194a
Cext_2102 dig_out[6] vss_1v2 377.071a
Cext_2103 dig_out[6] vss_3v3 297.657a
Cext_2104 dig_out[7] dig_out[8] 44.2813f
Cext_2105 dig_out[7] dig_out[9] 37.515a
Cext_2106 dig_out[7] enable 16.6493a
Cext_2107 dig_out[7] vbias 29.5657a
Cext_2108 dig_out[7] vdd_1v2 521.935a
Cext_2109 dig_out[7] vdd_3v3 95.6194a
Cext_2110 dig_out[7] vss_1v2 446.097a
Cext_2111 dig_out[7] vss_3v3 297.657a
Cext_2112 dig_out[8] dig_out[9] 44.3359f
Cext_2113 dig_out[8] enable 16.6493a
Cext_2114 dig_out[8] vbias 30.5376a
Cext_2115 dig_out[8] vdd_1v2 522.072a
Cext_2116 dig_out[8] vdd_3v3 95.6194a
Cext_2117 dig_out[8] vss_1v2 465.444a
Cext_2118 dig_out[8] vss_3v3 297.657a
Cext_2119 dig_out[9] enable 16.6493a
Cext_2120 dig_out[9] vbias 30.5043f
Cext_2121 dig_out[9] vdd_1v2 639.25a
Cext_2122 dig_out[9] vdd_3v3 95.6194a
Cext_2123 dig_out[9] vss_1v2 492.877a
Cext_2124 dig_out[9] vss_3v3 310.009a
Cext_2125 enable reset 203.67a
Cext_2126 enable vbias 212.691a
Cext_2127 enable vdd_1v2 750.532a
Cext_2128 enable vdd_3v3 369.247a
Cext_2129 enable vss_1v2 4.59323f
Cext_2130 enable vss_3v3 1.32102f
Cext_2131 gs gw 4.81711f
Cext_2132 gs vbias 428.843a
Cext_2133 gs vdd_1v2 388.807a
Cext_2134 gs vdd_3v3 1.62302f
Cext_2135 gs vss_3v3 972.402a
Cext_2136 gw vbias 122.124a
Cext_2137 gw vdd_1v2 611.206a
Cext_2138 gw vdd_3v3 2.61465f
Cext_2139 gw vss_3v3 618.952a
Cext_2140 ibias0 vss_1v2 37.8425a
Cext_2141 ibias1 vss_1v2 13.1087a
Cext_2142 reset vss_1v2 14.7279a
Cext_2143 rst s0 163.428a
Cext_2144 rst s1 230.354a
Cext_2145 rst s2 364.958a
Cext_2146 rst s3 11.3748a
Cext_2147 rst slow 37.455f
Cext_2148 rst vdd_3v3 5.09383f
Cext_2149 rst vin 72.9594f
Cext_2150 rst vss_3v3 4.77418f
Cext_2151 s0 s1 265.773a
Cext_2152 s0 slow 1.54942f
Cext_2153 s0 vdd_3v3 941.024a
Cext_2154 s0 vin 1.07207f
Cext_2155 s0 vss_3v3 446.368a
Cext_2156 s1 s2 2.8626a
Cext_2157 s1 slow 2.31969f
Cext_2158 s1 vdd_3v3 2.80977f
Cext_2159 s1 vin 664.64a
Cext_2160 s1 vss_3v3 1.42302f
Cext_2161 s2 slow 4.35154f
Cext_2162 s2 vdd_3v3 3.47556f
Cext_2163 s2 vin 1.1337f
Cext_2164 s2 vss_3v3 3.53188f
Cext_2165 s3 slow 1.24954f
Cext_2166 s3 vdd_3v3 3.50574f
Cext_2167 s3 vin 7.77971f
Cext_2168 s3 vss_3v3 5.35029f
Cext_2169 slow vdd_3v3 11.5595f
Cext_2170 slow vin 843.52a
Cext_2171 slow vss_3v3 38.8996f
Cext_2172 vbias vdd_1v2 269.347a
Cext_2173 vbias vdd_3v3 448.442a
Cext_2174 vbias vss_1v2 531.093a
Cext_2175 vbias vss_3v3 8.19879f
Cext_2176 vdd_1v2 vdd_3v3 2.81753f
Cext_2177 vdd_1v2 vss_1v2 5.5756f
Cext_2178 vdd_1v2 vss_3v3 5.44381f
Cext_2179 vdd_3v3 vin 8.68559f
Cext_2180 vdd_3v3 vss_1v2 1.66451f
Cext_2181 vdd_3v3 vss_3v3 163.861f
Cext_2182 vin vss_3v3 3.14674f
Cext_2183 vss_1v2 vss_3v3 6.48588f
Cext_2184 sub! analog_bus0 15.5742f
Cext_2185 sub! analog_bus1 3.90522f
Cext_2186 sub! analog_bus2 6.77241f
Cext_2187 sub! analog_bus3 15.2973f
Cext_2188 sub! bs 877.886a
Cext_2189 sub! bw 801.934a
Cext_2190 sub! clk 63.0269a
Cext_2191 sub! dig_in[0] 4.33347f
Cext_2192 sub! dig_in[10] 4.09398f
Cext_2193 sub! dig_in[11] 4.15917f
Cext_2194 sub! dig_in[12] 3.64731f
Cext_2195 sub! dig_in[13] 3.44844f
Cext_2196 sub! dig_in[14] 3.66924f
Cext_2197 sub! dig_in[15] 5.01767f
Cext_2198 sub! dig_in[16] 6.05984f
Cext_2199 sub! dig_in[17] 3.80658f
Cext_2200 sub! dig_in[18] 2.97477f
Cext_2201 sub! dig_in[19] 4.28507f
Cext_2202 sub! dig_in[1] 3.03012f
Cext_2203 sub! dig_in[20] 9.92143f
Cext_2204 sub! dig_in[21] 3.7061f
Cext_2205 sub! dig_in[22] 4.3922f
Cext_2206 sub! dig_in[23] 11.4753f
Cext_2207 sub! dig_in[2] 3.28018f
Cext_2208 sub! dig_in[3] 3.87687f
Cext_2209 sub! dig_in[4] 2.95936f
Cext_2210 sub! dig_in[5] 3.14483f
Cext_2211 sub! dig_in[6] 3.38605f
Cext_2212 sub! dig_in[7] 4.01742f
Cext_2213 sub! dig_in[8] 3.31031f
Cext_2214 sub! dig_in[9] 3.68759f
Cext_2215 sub! dig_out[0] 4.62578f
Cext_2216 sub! dig_out[10] 4.04344f
Cext_2217 sub! dig_out[11] 5.34965f
Cext_2218 sub! dig_out[1] 3.88524f
Cext_2219 sub! dig_out[2] 3.94922f
Cext_2220 sub! dig_out[3] 3.92852f
Cext_2221 sub! dig_out[4] 3.95219f
Cext_2222 sub! dig_out[5] 3.97622f
Cext_2223 sub! dig_out[6] 4.00313f
Cext_2224 sub! dig_out[7] 4.02772f
Cext_2225 sub! dig_out[8] 4.05021f
Cext_2226 sub! dig_out[9] 5.90984f
Cext_2227 sub! enable 15.5727f
Cext_2228 sub! gs 9.61838f
Cext_2229 sub! gw 8.87146f
Cext_2230 sub! ibias0 182.749a
Cext_2231 sub! ibias1 182.749a
Cext_2232 sub! reset 25.2743a
Cext_2233 sub! rst 17.3418f
Cext_2234 sub! s0 2.54643f
Cext_2235 sub! s1 3.9625f
Cext_2236 sub! s2 6.42536f
Cext_2237 sub! s3 12.4423f
Cext_2238 sub! slow 259.608f
Cext_2239 sub! vbias 18.3089f
Cext_2240 sub! vdd_1v2 48.3196f
Cext_2241 sub! vdd_3v3 336.925f
Cext_2242 sub! vin 22.6513f
Cext_2243 sub! vss_1v2 46.712f
Cext_2244 sub! vss_3v3 355.2f
.ENDS bbl_slot_shared

.SUBCKT bbl_tielo q0 vss vssl vddl q2 q1 q7 q6 q5 q4 q3 q10 q9 q8 q11 sub!
X$1 q0 vddl vssl sub! sg13_lv_nmos w=3e-07 l=5e-07 as=1.02e-13 ad=1.02e-13
+ ps=1.28e-06 pd=1.28e-06
X$2 q1 vddl vssl sub! sg13_lv_nmos w=3e-07 l=5e-07 as=1.02e-13 ad=1.02e-13
+ ps=1.28e-06 pd=1.28e-06
X$3 q2 vddl vssl sub! sg13_lv_nmos w=3e-07 l=5e-07 as=1.02e-13 ad=1.02e-13
+ ps=1.28e-06 pd=1.28e-06
X$4 q3 vddl vssl sub! sg13_lv_nmos w=3e-07 l=5e-07 as=1.02e-13 ad=1.02e-13
+ ps=1.28e-06 pd=1.28e-06
X$5 q4 vddl vssl sub! sg13_lv_nmos w=3e-07 l=5e-07 as=1.02e-13 ad=1.02e-13
+ ps=1.28e-06 pd=1.28e-06
X$6 q5 vddl vssl sub! sg13_lv_nmos w=3e-07 l=5e-07 as=1.02e-13 ad=1.02e-13
+ ps=1.28e-06 pd=1.28e-06
X$7 q6 vddl vssl sub! sg13_lv_nmos w=3e-07 l=5e-07 as=1.02e-13 ad=1.02e-13
+ ps=1.28e-06 pd=1.28e-06
X$8 q7 vddl vssl sub! sg13_lv_nmos w=3e-07 l=5e-07 as=1.02e-13 ad=1.02e-13
+ ps=1.28e-06 pd=1.28e-06
X$9 q8 vddl vssl sub! sg13_lv_nmos w=3e-07 l=5e-07 as=1.02e-13 ad=1.02e-13
+ ps=1.28e-06 pd=1.28e-06
X$10 q10 vddl vssl sub! sg13_lv_nmos w=3e-07 l=5e-07 as=1.02e-13 ad=1.02e-13
+ ps=1.28e-06 pd=1.28e-06
X$11 q11 vddl vssl sub! sg13_lv_nmos w=3e-07 l=5e-07 as=1.02e-13 ad=1.02e-13
+ ps=1.28e-06 pd=1.28e-06
X$12 q9 vddl vssl sub! sg13_lv_nmos w=3e-07 l=5e-07 as=1.02e-13 ad=1.02e-13
+ ps=1.28e-06 pd=1.28e-06
X$13 vss sub! ptap1
X$14 vss sub! ptap1
X$15 vss sub! ptap1
X$16 vss sub! ptap1
X$17 vss sub! ptap1
X$18 vss sub! ptap1
X$19 vss sub! ptap1
.ENDS bbl_tielo

.SUBCKT bbl_gap a vss vc enw ens b sub!
X$1 a vc gw sub! sg13_hv_nmos w=3e-07 l=1e-05 as=1.02e-13 ad=1.02e-13
+ ps=1.28e-06 pd=1.28e-06
X$2 gs ens b sub! sg13_hv_nmos w=1e-06 l=4.5e-07 as=3.4e-13 ad=3.4e-13
+ ps=2.68e-06 pd=2.68e-06
X$3 a vc gs sub! sg13_hv_nmos w=1e-06 l=4.5e-07 as=3.4e-13 ad=3.4e-13
+ ps=2.68e-06 pd=2.68e-06
X$4 gw enw b sub! sg13_hv_nmos w=3e-07 l=4.5e-07 as=1.02e-13 ad=1.02e-13
+ ps=1.28e-06 pd=1.28e-06
X$5 vss sub! ptap1
X$6 vss sub! ptap1
X$7 vss sub! ptap1
X$8 vss sub! ptap1
X$9 vss sub! ptap1
.ENDS bbl_gap

.SUBCKT bbl_inv a vdd y vss sub!
X$1 y a vss sub! sg13_hv_nmos w=1e-06 l=4.5e-07 as=3.4e-13 ad=3.4e-13
+ ps=2.68e-06 pd=2.68e-06
X$2 y a vdd \$5 sg13_hv_pmos w=1e-06 l=4.5e-07 as=3.4e-13 ad=3.4e-13
+ ps=2.68e-06 pd=2.68e-06
X$3 vdd \$5 ntap1
X$4 vdd \$5 ntap1
X$5 vss sub! ptap1
X$6 vss sub! ptap1
.ENDS bbl_inv

.SUBCKT bbl_syn vss enw ens spk vdd post sub!
X$1 post gw vdd \$19 sg13_hv_pmos w=3e-07 l=0.0001 as=1.02e-13 ad=1.02e-13
+ ps=1.28e-06 pd=1.28e-06
X$2 gs spk vdd \$19 sg13_hv_pmos w=3e-07 l=4.5e-07 as=1.02e-13 ad=1.02e-13
+ ps=1.28e-06 pd=1.28e-06
X$3 gw spk vdd \$19 sg13_hv_pmos w=3e-07 l=4.5e-07 as=1.02e-13 ad=1.02e-13
+ ps=1.28e-06 pd=1.28e-06
X$4 gw vss vdd \$19 sg13_hv_pmos w=3e-07 l=2e-05 as=1.02e-13 ad=1.02e-13
+ ps=1.28e-06 pd=1.28e-06
X$5 gs vss vdd \$19 sg13_hv_pmos w=3e-07 l=2e-05 as=1.02e-13 ad=1.02e-13
+ ps=1.28e-06 pd=1.28e-06
X$6 post gs vdd \$19 sg13_hv_pmos w=3e-07 l=2e-05 as=1.02e-13 ad=1.02e-13
+ ps=1.28e-06 pd=1.28e-06
X$7 bs spk vss sub! sg13_hv_nmos w=3e-07 l=4.5e-07 as=1.02e-13 ad=1.02e-13
+ ps=1.28e-06 pd=1.28e-06
X$8 bw spk vss sub! sg13_hv_nmos w=3e-07 l=4.5e-07 as=1.02e-13 ad=1.02e-13
+ ps=1.28e-06 pd=1.28e-06
X$9 gw enw bw sub! sg13_hv_nmos w=3e-07 l=4.5e-07 as=1.02e-13 ad=1.02e-13
+ ps=1.28e-06 pd=1.28e-06
X$10 gs ens bs sub! sg13_hv_nmos w=3e-07 l=4.5e-07 as=1.02e-13 ad=1.02e-13
+ ps=1.28e-06 pd=1.28e-06
X$11 vdd \$19 ntap1
X$12 vdd \$19 ntap1
X$13 vdd \$19 ntap1
X$14 vdd \$19 ntap1
X$15 vdd \$19 ntap1
X$16 vdd \$19 ntap1
X$17 vdd \$19 ntap1
X$18 vdd \$19 ntap1
X$19 vdd \$19 ntap1
X$20 vdd \$19 ntap1
X$21 vdd \$19 ntap1
X$22 vdd \$19 ntap1
X$23 vdd \$19 ntap1
X$24 vdd \$19 ntap1
X$25 vdd \$19 ntap1
X$26 vdd \$19 ntap1
X$27 vdd \$19 ntap1
X$28 vdd \$19 ntap1
X$29 vdd \$19 ntap1
X$30 vdd \$19 ntap1
X$31 vdd \$19 ntap1
X$32 vdd \$19 ntap1
X$33 vdd \$19 ntap1
X$34 vdd \$19 ntap1
X$35 vdd \$19 ntap1
X$36 vdd \$19 ntap1
X$37 vdd \$19 ntap1
X$38 vdd \$19 ntap1
X$39 vdd \$19 ntap1
X$40 vdd \$19 ntap1
X$41 vdd \$19 ntap1
X$42 vdd \$19 ntap1
X$43 vdd \$19 ntap1
X$44 vdd \$19 ntap1
X$45 vdd \$19 ntap1
X$46 vdd \$19 ntap1
X$47 vdd \$19 ntap1
X$48 vdd \$19 ntap1
X$49 vdd \$19 ntap1
X$50 vdd \$19 ntap1
X$51 vdd \$19 ntap1
X$52 vdd \$19 ntap1
X$53 vdd \$19 ntap1
X$54 vss sub! ptap1
X$55 vss sub! ptap1
X$56 vss sub! ptap1
X$57 vss sub! ptap1
X$58 vss sub! ptap1
X$59 vss sub! ptap1
X$60 vss sub! ptap1
X$61 vss sub! ptap1
X$62 vss sub! ptap1
X$63 vss sub! ptap1
X$64 vss sub! ptap1
X$65 vss sub! ptap1
X$66 vss sub! ptap1
X$67 vss sub! ptap1
X$68 vss sub! ptap1
X$69 vss sub! ptap1
X$70 vss sub! ptap1
X$71 vss sub! ptap1
X$72 vss sub! ptap1
X$73 vss sub! ptap1
X$74 vss sub! ptap1
X$75 vss sub! ptap1
X$76 vss sub! ptap1
X$77 vss sub! ptap1
X$78 vss sub! ptap1
X$79 vss sub! ptap1
X$80 vss sub! ptap1
X$81 vss sub! ptap1
X$82 vss sub! ptap1
X$83 vss sub! ptap1
X$84 vss sub! ptap1
X$85 vss sub! ptap1
X$86 vss sub! ptap1
X$87 vss sub! ptap1
X$88 vss sub! ptap1
X$89 vss sub! ptap1
X$90 vss sub! ptap1
X$91 vss sub! ptap1
X$92 vss sub! ptap1
X$93 vss sub! ptap1
X$94 vss sub! ptap1
X$95 vss sub! ptap1
X$96 vss sub! ptap1
.ENDS bbl_syn

.SUBCKT bbl_unit vss vm vbnl b0 b1 b2 b3 vdd out sub!
X$1 vm rst vss sub! sg13_hv_nmos w=2e-06 l=4.5e-07 as=6.8e-13 ad=6.8e-13
+ ps=4.68e-06 pd=4.68e-06
X$2 out vm vss sub! sg13_hv_nmos w=1e-06 l=1e-06 as=3.4e-13 ad=3.4e-13
+ ps=2.68e-06 pd=2.68e-06
X$3 vin vin vdd \$30 sg13_hv_pmos w=3e-06 l=3e-06 as=1.02e-12 ad=1.02e-12
+ ps=6.68e-06 pd=6.68e-06
X$4 vm vin vdd \$30 sg13_hv_pmos w=3e-07 l=3e-05 as=1.02e-13 ad=1.02e-13
+ ps=1.28e-06 pd=1.28e-06
X$5 slow vdd out sub! sg13_hv_nmos w=3e-07 l=0.0001 as=1.02e-13 ad=1.02e-13
+ ps=1.28e-06 pd=1.28e-06
X$6 rst vdd vss sub! sg13_hv_nmos w=3e-07 l=2e-05 as=1.02e-13 ad=1.02e-13
+ ps=1.28e-06 pd=1.28e-06
X$7 rst slow vdd \$30 sg13_hv_pmos w=1e-06 l=4.5e-07 as=3.4e-13 ad=3.4e-13
+ ps=2.68e-06 pd=2.68e-06
X$8 out vss vdd \$30 sg13_hv_pmos w=3e-07 l=2e-05 as=1.02e-13 ad=1.02e-13
+ ps=1.28e-06 pd=1.28e-06
X$9 s3 b3 vss sub! sg13_hv_nmos w=3e-07 l=4.5e-07 as=1.02e-13 ad=5.7e-14
+ ps=1.28e-06 pd=6.8e-07
X$10 vss b3 s3 sub! sg13_hv_nmos w=3e-07 l=4.5e-07 as=5.7e-14 ad=5.7e-14
+ ps=6.8e-07 pd=6.8e-07
X$11 s3 b3 vss sub! sg13_hv_nmos w=3e-07 l=4.5e-07 as=5.7e-14 ad=5.7e-14
+ ps=6.8e-07 pd=6.8e-07
X$12 vss b3 s3 sub! sg13_hv_nmos w=3e-07 l=4.5e-07 as=5.7e-14 ad=5.7e-14
+ ps=6.8e-07 pd=6.8e-07
X$13 s3 b3 vss sub! sg13_hv_nmos w=3e-07 l=4.5e-07 as=5.7e-14 ad=5.7e-14
+ ps=6.8e-07 pd=6.8e-07
X$14 vss b3 s3 sub! sg13_hv_nmos w=3e-07 l=4.5e-07 as=5.7e-14 ad=5.7e-14
+ ps=6.8e-07 pd=6.8e-07
X$15 s3 b3 vss sub! sg13_hv_nmos w=3e-07 l=4.5e-07 as=5.7e-14 ad=5.7e-14
+ ps=6.8e-07 pd=6.8e-07
X$16 vss b3 s3 sub! sg13_hv_nmos w=3e-07 l=4.5e-07 as=5.7e-14 ad=1.02e-13
+ ps=6.8e-07 pd=1.28e-06
X$17 vin vbnl s3 sub! sg13_hv_nmos w=3e-07 l=2e-06 as=1.02e-13 ad=5.7e-14
+ ps=1.28e-06 pd=6.8e-07
X$18 s3 vbnl vin sub! sg13_hv_nmos w=3e-07 l=2e-06 as=5.7e-14 ad=5.7e-14
+ ps=6.8e-07 pd=6.8e-07
X$19 vin vbnl s3 sub! sg13_hv_nmos w=3e-07 l=2e-06 as=5.7e-14 ad=5.7e-14
+ ps=6.8e-07 pd=6.8e-07
X$20 s3 vbnl vin sub! sg13_hv_nmos w=3e-07 l=2e-06 as=5.7e-14 ad=5.7e-14
+ ps=6.8e-07 pd=6.8e-07
X$21 vin vbnl s3 sub! sg13_hv_nmos w=3e-07 l=2e-06 as=5.7e-14 ad=5.7e-14
+ ps=6.8e-07 pd=6.8e-07
X$22 s3 vbnl vin sub! sg13_hv_nmos w=3e-07 l=2e-06 as=5.7e-14 ad=5.7e-14
+ ps=6.8e-07 pd=6.8e-07
X$23 vin vbnl s3 sub! sg13_hv_nmos w=3e-07 l=2e-06 as=5.7e-14 ad=5.7e-14
+ ps=6.8e-07 pd=6.8e-07
X$24 s3 vbnl vin sub! sg13_hv_nmos w=3e-07 l=2e-06 as=5.7e-14 ad=1.02e-13
+ ps=6.8e-07 pd=1.28e-06
X$25 s2 b2 vss sub! sg13_hv_nmos w=3e-07 l=4.5e-07 as=1.02e-13 ad=5.7e-14
+ ps=1.28e-06 pd=6.8e-07
X$26 vss b2 s2 sub! sg13_hv_nmos w=3e-07 l=4.5e-07 as=5.7e-14 ad=5.7e-14
+ ps=6.8e-07 pd=6.8e-07
X$27 s2 b2 vss sub! sg13_hv_nmos w=3e-07 l=4.5e-07 as=5.7e-14 ad=5.7e-14
+ ps=6.8e-07 pd=6.8e-07
X$28 vss b2 s2 sub! sg13_hv_nmos w=3e-07 l=4.5e-07 as=5.7e-14 ad=1.02e-13
+ ps=6.8e-07 pd=1.28e-06
X$29 vin vbnl s2 sub! sg13_hv_nmos w=3e-07 l=2e-06 as=1.02e-13 ad=5.7e-14
+ ps=1.28e-06 pd=6.8e-07
X$30 s2 vbnl vin sub! sg13_hv_nmos w=3e-07 l=2e-06 as=5.7e-14 ad=5.7e-14
+ ps=6.8e-07 pd=6.8e-07
X$31 vin vbnl s2 sub! sg13_hv_nmos w=3e-07 l=2e-06 as=5.7e-14 ad=5.7e-14
+ ps=6.8e-07 pd=6.8e-07
X$32 s2 vbnl vin sub! sg13_hv_nmos w=3e-07 l=2e-06 as=5.7e-14 ad=1.02e-13
+ ps=6.8e-07 pd=1.28e-06
X$33 s1 b1 vss sub! sg13_hv_nmos w=3e-07 l=4.5e-07 as=1.02e-13 ad=5.7e-14
+ ps=1.28e-06 pd=6.8e-07
X$34 vss b1 s1 sub! sg13_hv_nmos w=3e-07 l=4.5e-07 as=5.7e-14 ad=1.02e-13
+ ps=6.8e-07 pd=1.28e-06
X$35 vin vbnl s1 sub! sg13_hv_nmos w=3e-07 l=2e-06 as=1.02e-13 ad=5.7e-14
+ ps=1.28e-06 pd=6.8e-07
X$36 s1 vbnl vin sub! sg13_hv_nmos w=3e-07 l=2e-06 as=5.7e-14 ad=1.02e-13
+ ps=6.8e-07 pd=1.28e-06
X$37 s0 b0 vss sub! sg13_hv_nmos w=3e-07 l=4.5e-07 as=1.02e-13 ad=1.02e-13
+ ps=1.28e-06 pd=1.28e-06
X$38 vin vbnl s0 sub! sg13_hv_nmos w=3e-07 l=2e-06 as=1.02e-13 ad=1.02e-13
+ ps=1.28e-06 pd=1.28e-06
X$39 vin vbnl vss sub! sg13_hv_nmos w=3e-07 l=9e-06 as=1.02e-13 ad=1.02e-13
+ ps=1.28e-06 pd=1.28e-06
X$40 slow vin vdd \$30 sg13_hv_pmos w=3e-07 l=4e-06 as=1.02e-13 ad=1.02e-13
+ ps=1.28e-06 pd=1.28e-06
X$41 vm out vdd \$30 sg13_hv_pmos w=3e-07 l=4e-06 as=1.02e-13 ad=1.02e-13
+ ps=1.28e-06 pd=1.28e-06
X$42 vdd \$30 ntap1
X$43 vdd \$30 ntap1
X$44 vdd \$30 ntap1
X$45 vdd \$30 ntap1
X$46 vdd \$30 ntap1
X$47 vdd \$30 ntap1
X$48 vdd \$30 ntap1
X$49 vdd \$30 ntap1
X$50 vdd \$30 ntap1
X$51 vdd \$30 ntap1
X$52 vdd \$30 ntap1
X$53 vdd \$30 ntap1
X$54 vdd \$30 ntap1
X$55 vdd \$30 ntap1
X$56 vdd \$30 ntap1
X$57 vdd \$30 ntap1
X$58 vdd \$30 ntap1
X$59 vdd \$30 ntap1
X$60 vdd \$30 ntap1
X$61 vdd \$30 ntap1
X$62 vdd \$30 ntap1
X$63 vdd \$30 ntap1
X$64 vdd \$30 ntap1
X$65 vdd \$30 ntap1
X$66 vdd \$30 ntap1
X$67 vdd \$30 ntap1
X$68 vdd \$30 ntap1
X$69 vdd \$30 ntap1
X$70 vdd \$30 ntap1
X$71 vdd \$30 ntap1
X$72 vdd \$30 ntap1
X$73 vdd \$30 ntap1
X$74 vdd \$30 ntap1
X$75 vdd \$30 ntap1
X$76 vdd \$30 ntap1
X$77 vdd \$30 ntap1
X$78 vdd \$30 ntap1
X$79 vdd \$30 ntap1
X$80 vdd \$30 ntap1
X$81 vdd \$30 ntap1
X$82 vdd \$30 ntap1
X$83 vdd \$30 ntap1
X$84 vdd \$30 ntap1
X$85 vdd \$30 ntap1
X$86 vdd \$30 ntap1
X$87 vdd \$30 ntap1
X$88 vdd \$30 ntap1
X$89 vdd \$30 ntap1
X$90 vdd \$30 ntap1
X$91 vdd \$30 ntap1
X$92 vdd \$30 ntap1
X$93 vdd \$30 ntap1
X$94 vdd \$30 ntap1
X$95 vdd \$30 ntap1
X$96 vdd \$30 ntap1
X$97 vdd \$30 ntap1
X$98 vdd \$30 ntap1
X$99 vdd \$30 ntap1
X$100 vdd \$30 ntap1
X$101 vdd \$30 ntap1
X$102 vdd \$30 ntap1
X$103 vdd \$30 ntap1
X$104 vdd \$30 ntap1
X$105 vdd \$30 ntap1
X$106 vdd \$30 ntap1
X$107 vdd \$30 ntap1
X$108 vdd \$30 ntap1
X$109 vdd \$30 ntap1
X$110 vdd \$30 ntap1
X$111 vdd \$30 ntap1
X$112 vdd \$30 ntap1
X$113 vss sub! ptap1
X$114 vss sub! ptap1
X$115 vss sub! ptap1
X$116 vss sub! ptap1
X$117 vss sub! ptap1
X$118 vss sub! ptap1
X$119 vss sub! ptap1
X$120 vss sub! ptap1
X$121 vss sub! ptap1
X$122 vss sub! ptap1
X$123 vss sub! ptap1
X$124 vss sub! ptap1
X$125 vss sub! ptap1
X$126 vss sub! ptap1
X$127 vss sub! ptap1
X$128 vss sub! ptap1
X$129 vss sub! ptap1
X$130 vss sub! ptap1
X$131 vss sub! ptap1
X$132 vss sub! ptap1
X$133 vss sub! ptap1
X$134 vss sub! ptap1
X$135 vss sub! ptap1
X$136 vss sub! ptap1
X$137 vss sub! ptap1
X$138 vss sub! ptap1
X$139 vss sub! ptap1
X$140 vss sub! ptap1
X$141 vss sub! ptap1
X$142 vss sub! ptap1
X$143 vss sub! ptap1
X$144 vss sub! ptap1
X$145 vss sub! ptap1
X$146 vss sub! ptap1
X$147 vss sub! ptap1
X$148 vss sub! ptap1
X$149 vss sub! ptap1
X$150 vss sub! ptap1
X$151 vss sub! ptap1
X$152 vss sub! ptap1
X$153 vss sub! ptap1
X$154 vss sub! ptap1
X$155 vss sub! ptap1
X$156 vss sub! ptap1
X$157 vss sub! ptap1
X$158 vss sub! ptap1
X$159 vss sub! ptap1
X$160 vss sub! ptap1
X$161 vss sub! ptap1
X$162 vss sub! ptap1
X$163 vss sub! ptap1
X$164 vss sub! ptap1
X$165 vss sub! ptap1
X$166 vss sub! ptap1
X$167 vss sub! ptap1
X$168 vss sub! ptap1
X$169 vss sub! ptap1
X$170 vss sub! ptap1
X$171 vss sub! ptap1
X$172 vss sub! ptap1
X$173 vss sub! ptap1
X$174 vss sub! ptap1
X$175 vss sub! ptap1
X$176 vss sub! ptap1
X$177 vss sub! ptap1
X$178 vss sub! ptap1
X$179 vss sub! ptap1
X$180 vss sub! ptap1
X$181 vss sub! ptap1
X$182 vss sub! ptap1
X$183 vss sub! ptap1
X$184 vss slow vss sub! sg13_hv_nmos w=1e-05 l=1e-05 as=3.4e-12 ad=1.9e-12
+ ps=2.068e-05 pd=1.038e-05
X$185 vss slow vss sub! sg13_hv_nmos w=1e-05 l=1e-05 as=1.9e-12 ad=1.9e-12
+ ps=1.038e-05 pd=1.038e-05
X$186 vss slow vss sub! sg13_hv_nmos w=1e-05 l=1e-05 as=1.9e-12 ad=1.9e-12
+ ps=1.038e-05 pd=1.038e-05
X$187 vss slow vss sub! sg13_hv_nmos w=1e-05 l=1e-05 as=1.9e-12 ad=1.9e-12
+ ps=1.038e-05 pd=1.038e-05
X$188 vss slow vss sub! sg13_hv_nmos w=1e-05 l=1e-05 as=1.9e-12 ad=1.9e-12
+ ps=1.038e-05 pd=1.038e-05
X$189 vss slow vss sub! sg13_hv_nmos w=1e-05 l=1e-05 as=1.9e-12 ad=3.4e-12
+ ps=1.038e-05 pd=2.068e-05
X$190 vdd vm vdd \$30 sg13_hv_pmos w=1.25e-05 l=1e-05 as=4.25e-12 ad=2.375e-12
+ ps=2.568e-05 pd=1.288e-05
X$191 vdd vm vdd \$30 sg13_hv_pmos w=1.25e-05 l=1e-05 as=2.375e-12 ad=2.375e-12
+ ps=1.288e-05 pd=1.288e-05
X$192 vdd vm vdd \$30 sg13_hv_pmos w=1.25e-05 l=1e-05 as=2.375e-12 ad=2.375e-12
+ ps=1.288e-05 pd=1.288e-05
X$193 vdd vm vdd \$30 sg13_hv_pmos w=1.25e-05 l=1e-05 as=2.375e-12 ad=2.375e-12
+ ps=1.288e-05 pd=1.288e-05
X$194 vdd vm vdd \$30 sg13_hv_pmos w=1.25e-05 l=1e-05 as=2.375e-12 ad=2.375e-12
+ ps=1.288e-05 pd=1.288e-05
X$195 vdd vm vdd \$30 sg13_hv_pmos w=1.25e-05 l=1e-05 as=2.375e-12 ad=2.375e-12
+ ps=1.288e-05 pd=1.288e-05
X$196 vdd vm vdd \$30 sg13_hv_pmos w=1.25e-05 l=1e-05 as=2.375e-12 ad=2.375e-12
+ ps=1.288e-05 pd=1.288e-05
X$197 vdd vm vdd \$30 sg13_hv_pmos w=1.25e-05 l=1e-05 as=2.375e-12 ad=2.375e-12
+ ps=1.288e-05 pd=1.288e-05
X$198 vdd vm vdd \$30 sg13_hv_pmos w=1.25e-05 l=1e-05 as=2.375e-12 ad=2.375e-12
+ ps=1.288e-05 pd=1.288e-05
X$199 vdd vm vdd \$30 sg13_hv_pmos w=1.25e-05 l=1e-05 as=2.375e-12 ad=2.375e-12
+ ps=1.288e-05 pd=1.288e-05
X$200 vdd vm vdd \$30 sg13_hv_pmos w=1.25e-05 l=1e-05 as=2.375e-12 ad=2.375e-12
+ ps=1.288e-05 pd=1.288e-05
X$201 vdd vm vdd \$30 sg13_hv_pmos w=1.25e-05 l=1e-05 as=2.375e-12 ad=2.375e-12
+ ps=1.288e-05 pd=1.288e-05
X$202 vdd vm vdd \$30 sg13_hv_pmos w=1.25e-05 l=1e-05 as=2.375e-12 ad=2.375e-12
+ ps=1.288e-05 pd=1.288e-05
X$203 vdd vm vdd \$30 sg13_hv_pmos w=1.25e-05 l=1e-05 as=2.375e-12 ad=2.375e-12
+ ps=1.288e-05 pd=1.288e-05
X$204 vdd vm vdd \$30 sg13_hv_pmos w=1.25e-05 l=1e-05 as=2.375e-12 ad=2.375e-12
+ ps=1.288e-05 pd=1.288e-05
X$205 vdd vm vdd \$30 sg13_hv_pmos w=1.25e-05 l=1e-05 as=2.375e-12 ad=2.375e-12
+ ps=1.288e-05 pd=1.288e-05
X$206 vdd vm vdd \$30 sg13_hv_pmos w=1.25e-05 l=1e-05 as=2.375e-12 ad=2.375e-12
+ ps=1.288e-05 pd=1.288e-05
X$207 vdd vm vdd \$30 sg13_hv_pmos w=1.25e-05 l=1e-05 as=2.375e-12 ad=4.25e-12
+ ps=1.288e-05 pd=2.568e-05
.ENDS bbl_unit
